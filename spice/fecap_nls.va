// fecap_nls.va -- dynamic multi-domain NLS ferroelectric capacitor (Verilog-A)
//
// Mean-field, deterministic form of the dynamic nucleation-limited-switching
// (NLS) picture for HfO2-type thin-film capacitors.  The film is split into
// FE_ND classes of domains ordered by how hard they are to switch; each class
// carries a switching state s_k in [-1, +1] and (for beta > 1) a signed
// nucleation-progress variable h_k.  Full equations and parameter sources:
// spice/README.md.  Python reference implementation (same equations):
// src/fe_models/nls_multidomain.py.
//
// Terminals
//   p, n : capacitor terminals.  V(p,n) > 0 drives the polarization toward +.
//          I(p,n) = area * [ d(P + q_rev)/dt + J_leak(V) ].
//   qm   : monitor output, V(qm) = terminal charge density P + q_rev in
//          uC/cm^2 (1 V == 1 uC/cm^2).  Leave it open (it is driven by an
//          ideal voltage source inside the model).  At 0 V with y = 0 it equals
//          the remanent polarization Ps * x.
//
// Internal nodes (2*FE_ND + 2): s_k, h_k (k = 1..FE_ND), the low-pass voltage
// y and the screening state sigma.  All of them are dimensionless except y
// (volts).  The cycling/storage history adds FE_NI + 4 nodes (E13-E17): the
// pinned polarization pi, the frozen reversible charge r of the pinned pool
// (C/m^2), the wake-up age a_w, the fatigue age a_F and the imprint states
// sigma_j.  A history term that is off (the default) keeps its
// nodes at exactly 0, so the default card behaves as without them.  The second
// round (E18-E20) adds FE_NQ + 1 nodes: the reversible depinning states z_j
// and the lagged voltage V_L of the field-time fatigue driver, both kept at 0
// while off.  Their equations are written as I(node) <+ FE_TC*(ddt(X) - f(X)),
// i.e. dX/dt = f(X); FE_TC only scales the "current" of these nodes.
//
// Compile-time options
//   FE_ND : number of domain classes (default 16), e.g. openvaf-r -D FE_ND=64
//   FE_NI : number of imprint states (default 12)
//   FE_NQ : number of reversible depinning states (default 8)
//
// Defaults are the generic, literature-based card of spice/params/generic.inc.
// They are not fitted to any particular device.
//
// Changes relative to the earlier, never-compiled draft of this model (the
// physics is unchanged; see spice/README.md, "Changes found by the compiler"):
//   * initial-state selection uses (analysis("static") || $abstime <= 0):
//     ngspice's OSDI interface does not report analysis("static") during the
//     transient operating point, which left the state nodes singular;
//   * the two leakage exponentials are capped at exp(80) as in the Python
//     reference;
//   * area, s0 and sg0 are instance parameters; the monitor output is in
//     uC/cm^2 instead of fC.

`include "disciplines.vams"

`ifndef FE_ND
`define FE_ND 16
`endif
`ifndef FE_NI
`define FE_NI 12
`endif
`ifndef FE_NQ
`define FE_NQ 8
`endif
// scale of the state-node "currents" (A per unit of dX/dt); numerical only
`define FE_TC 1.0e-6
// physical constants
`define FE_KQ 8.617333262e-5
`define FE_BS 3.794686480e-05

module fecap_nls(p, n, qm);
inout p, n, qm;
electrical p, n, qm;
electrical [1:`FE_ND] sn, hn;
electrical yn, gn;
electrical pn, prn, awn, afn;
electrical [1:`FE_NI] imn;
electrical [1:`FE_NQ] dqn;
electrical fln;

// ---------------------------------------------------------------- geometry
(*type="instance"*) parameter real area = 1.0e-10 from (0:inf);   // capacitor area [m^2]
parameter real tfe = 1.0e-8 from (0:inf);                          // ferroelectric thickness [m]
parameter real t0 = 298.15 from (0:inf);                           // reference temperature [K]
(*type="instance"*) parameter real s0 = -1.0 from [-1:1];          // initial state of every class [1]
(*type="instance"*) parameter real sg0 = 0.0 from [-1:1];          // initial screening state, sigma(0) = s0*sg0 [1]
(*type="instance"*) parameter real nw0 = 0.0 from [0:inf);         // prior equivalent full switching cycles (wake-up history) [1]
(*type="instance"*) parameter real af0 = 0.0 from [0:inf);         // prior fatigue age a_F (dimensionless) [1]
(*type="instance"*) parameter real si0 = 0.0 from [-1:1];          // initial value of every imprint state sigma_j [1]
(*type="instance"*) parameter real zq0 = 0.0 from [0:1];           // initial value of every depinning state z_j (E18) [1]

// ------------------------------------------------- polarization, switching
parameter real ps = 0.229 from [0:inf);        // saturation polarization Ps [C/m^2]
parameter real emp = 1.775e8 from (0:inf);     // Dagum scale b+ of the activation field, + direction [V/m]
parameter real emn = 1.775e8 from (0:inf);     // Dagum scale b- of the activation field, - direction [V/m]
parameter real ap = 8.68 from (0:inf);         // Dagum shape a+ [1]
parameter real an = 8.68 from (0:inf);         // Dagum shape a- [1]
parameter real pt = 1.136 from (0:inf);        // Dagum shape p (both directions) [1]
parameter real alpha = 4.11 from (0:inf);      // Merz-type exponent alpha [1]
parameter real beta = 2.07 from [1:inf);       // Weibull exponent beta [1]
parameter real tau0 = 3.87e-7 from (0:inf);    // attempt time tau_0 (tau_inf) [s]
parameter real tau_h = 3.7e-6 from (0:inf);    // relaxation time of h without drive [s]
parameter real vimp = -0.08;                   // built-in (imprint) voltage V_imp [V]
parameter real rho = 1.0 from (0:1];           // voltage division factor C_i/(C_i+C_f) [1]
parameter real vdep = 0.0;                     // depolarization voltage V_dep (0 = off) [V]
parameter real tau_s = 1.0e-4 from (0:inf);    // screening time constant tau_s [s]
parameter real sb = 0.0 from [0:inf);          // spread of per-class offsets delta_k (0 = off) [V]

// ------------------------------------------------------ reversible response
parameter real c_d = 0.02055;                  // (1) linear dielectric capacitance C_d [F/m^2]
parameter real dcap = 0.03023;                 // (2) peak height of each reversible branch Delta C [F/m^2]
parameter real frev = 1.0 from [0:1];          // instantaneous fraction of term (2) [1]
parameter real c_w = 0.0;                      // (3) reversible domain-wall capacitance C_w [F/m^2]
parameter real vw = 2.236 from (0:inf);        // half width of each branch V_w [V]
parameter real vs = 3.006;                     // distance of each branch peak from V_i, V_s [V]
parameter real vi = 0.0;                       // crossing voltage of the two branches V_i [V]
parameter real c_r = 0.0;                      // state-independent slow capacitance C_r [F/m^2]
parameter real tau_r = 1.0e-7 from (0:inf);    // low-pass time constant of y [s]

// ----------------------------------------------------------------- leakage
parameter real g_oh = 1.0e-4;                  // ohmic conductance per area G_ohm [A/m^2/V]
parameter real phi_oh = 0.0;                   // activation energy of G_ohm [eV]
parameter real spf_p = 4.8e-12;                // Poole-Frenkel prefactor, V > 0 [S/m]
parameter real spf_n = 4.8e-12;                // Poole-Frenkel prefactor, V < 0 [S/m]
parameter real phit_p = 0.68;                  // PF trap depth, V > 0 [eV]
parameter real phit_n = 0.68;                  // PF trap depth, V < 0 [eV]
parameter real eps_op = 70.0 from (0:inf);     // permittivity used in the barrier lowering [1]
parameter real js_p = 0.0;                     // Schottky prefactor at t0, V > 0 (0 = off) [A/m^2]
parameter real js_n = 0.0;                     // Schottky prefactor at t0, V < 0 (0 = off) [A/m^2]
parameter real phib_p = 0.48;                  // Schottky barrier, V > 0 [eV]
parameter real phib_n = 0.48;                  // Schottky barrier, V < 0 [eV]
parameter real jt_p = 0.0;                     // trap-assisted tunnelling prefactor, V > 0 (0 = off) [A/m^2]
parameter real jt_n = 0.0;                     // trap-assisted tunnelling prefactor, V < 0 (0 = off) [A/m^2]
parameter real et_p = 1.0e9;                   // TAT characteristic field, V > 0 [V/m]
parameter real et_n = 1.0e9;                   // TAT characteristic field, V < 0 [V/m]
parameter real e0_leak = 1.0e6 from (0:inf);   // field regularization near 0 V (numerical) [V/m]

// --------------------------------------- temperature coefficients and hooks
parameter real tc_ea = 0.0;                    // linear temperature coefficient of the activation field [1/K]
parameter real tc_ps = 0.0;                    // linear temperature coefficient of Ps [1/K]
parameter real tc_tau = 0.0;                   // linear temperature coefficient of tau_0 [1/K]
parameter real tc_c = 0.0;                     // linear temperature coefficient of term (1)+(2) [1/K]
parameter real mul_ps = 1.0;                   // multiplier on Ps (variation / fatigue hook) [1]
parameter real mul_ea = 1.0;                   // multiplier on the activation field (variation hook) [1]

// ------------------------------- cycling and storage history (all off by default)
parameter real wk_fp = 0.0 from [0:1);         // pristine pinned fraction f_p0, released by wake-up [1]
parameter real wk_vsp = 0.0;                   // pristine internal-bias split +-V_sp on alternating classes [V]
parameter real wk_nw = 1.0e3 from (0:inf);     // wake-up constant N_w in equivalent full switching cycles [1]
parameter real wk_kw = 1.0 from (0:inf);       // stretch exponent kappa_w of the wake-up law [1]
parameter real wk_ea = 0.0;                    // activation energy of the wake-up rate [eV]
parameter real fat_d = 0.0 from [0:1);         // largest fraction D_max pinned by fatigue [1]
parameter real fat_tf = 1.0 from [0:inf);      // field-time fatigue: stress time t_F at 1 MV/cm (0 = off) [s]
parameter real fat_ns = 0.0 from [0:inf);      // switching fatigue: full cycles N_F switched at 1 MV/cm (0 = off) [1]
parameter real fat_nf = 4.0 from [0:inf);      // field exponent n_F of both fatigue drivers [1]
parameter real fat_ea = 0.0;                   // activation energy of both fatigue drivers [eV]
parameter real fat_kf = 1.0 from (0:inf);      // stretch exponent kappa_F of the fatigue law [1]
parameter real fat_ke = 0.0;                   // activation-field increase per unit damage k_E [1]
parameter real imp_v = 0.0;                    // imprint bias V_I at full trapped-charge screening [V]
parameter real imp_t1 = 1.0e-7 from (0:inf);   // shortest imprint time constant at t0 [s]
parameter real imp_t2 = 1.0e5 from (0:inf);    // longest imprint time constant at t0 [s]
parameter real imp_ea = 0.0;                   // activation energy of the imprint time constants [eV]

// -------------------------------------------------- sampling and numerics
parameter real y_max = 9.0 from (0:inf);       // depth of the logit quantile grid [1]
parameter real grid_a = 1.5 from (0:inf);      // sinh stretching of the quantile grid [1]
parameter real bnd = 0.1 from (0:inf);         // max state change per time step used by $bound_step [1]

// ------------------------- cycling, second round (E18-E20; all off by default)
parameter real wk_fq = 0.0 from [0:1);         // fraction pinned by mobile defects, depinned under field (E18) [1]
parameter real wk_rho = 0.0 from [0:inf);      // re-pinning at rest: rate / depinning rate at 1 MV/cm [1]
parameter real wk_tr = 0.0 from [0:inf);       // re-pinning per full switching cycle, in s of depinning at 1 MV/cm [s]
parameter real wk_q1 = 1.0e-2 from (0:inf);    // shortest depinning time constant at 1 MV/cm and t0 [s]
parameter real wk_q2 = 1.0e2 from (0:inf);     // longest depinning time constant at 1 MV/cm and t0 [s]
parameter real wk_nq = 2.0 from [0:inf);       // field exponent of the depinning drive [1]
parameter real fat_tl = 0.0 from [0:inf);      // build-up time t_L of the field-time stress, E_s^2 = max(E E_L, 0) (E19; 0 = none) [s]
parameter real fat_lk = 0.0 from [0:inf);      // leakage increase per unit fatigue age, J (1 + k_L a_F^m_L) (E20) [1]
parameter real fat_lm = 1.0 from (0:inf);      // exponent of the fatigue-induced leakage increase [1]
// ------------------------- imprint dynamics, round 2 (E17a, E17b; off by default)
parameter real imp_kw = 0.0;                   // branch asymmetry kappa_I: switching fields move outward by kappa_I V_I |sigma_I| [1]
parameter real imp_va = 0.0 from [0:inf);      // field acceleration of the imprint rates, x cosh(rho V / V_a) (0 = off) [V]

genvar i;
real kst, ux, v, tk, dtk, vth, vth0, te, tau, ptc, kc, zmin, relax, zv, x, sg, yv, rm;
real yl, yh, ql, qh, qm_k, vp, vn, dl, phi, u, rp, rn, s, h, hu, hd, cu, cd, ru, rd, ds, dh;
real gp, gm_, rev;
real enw, enf, eni, aw, af, piv, gw, dgw, uw, gf, dgf, ef, dmg, ddm, fw, fpn, dfaw, dfaf, sI, vimpe, me, xt;
real act, daw, daf, efl, fdot, fpin, frel, ratio, sgn, tauj, ar_i, vie, t2, fff, rtf, rns;
real gu, gd, guy, gdy, gb, gmm, qt, wi, gacc, vse;
real enq, enl, zb, gq, dfz, phq, dzq, dzb, tq, arq, vlf, efll, fffl, lkf;
real es, eroot, ar, jl, spf, phit, js, phib, jt, et;

analog begin
    // Static analyses (DC operating point, including the transient one at
    // t = 0) pin every state to its initial value; afterwards the states obey
    // their rate equations.  ngspice/OSDI does not set analysis("static") for
    // the transient operating point, hence the $abstime test.
    kst = 0.0;
    if (analysis("static") || $abstime <= 0.0) kst = 1.0;

    v = V(p, n);
    yv = V(yn);
    sg = V(gn);

    // temperature-dependent prefactors (linear coefficients; 0 by default)
    tk = $temperature;
    dtk = tk - t0;
    vth = `FE_KQ * tk;
    vth0 = `FE_KQ * t0;
    te = (1.0 + tc_ea * dtk) * mul_ea * tfe;    // field -> voltage, with T and variation hooks
    tau = tau0 * (1.0 + tc_tau * dtk);
    ptc = ps * mul_ps * (1.0 + tc_ps * dtk);
    kc = 1.0 + tc_c * dtk;

    // (E13-E17) cycling and storage history.  Each term is switched on by its
    // amplitude parameter; when off, its nodes stay at exactly 0.
    enw = 0.0; enf = 0.0; eni = 0.0;
    if (wk_fp > 0.0 || wk_vsp != 0.0) enw = 1.0;
    if (fat_d > 0.0 || fat_lk > 0.0) enf = 1.0;
    if (imp_v != 0.0) eni = 1.0;
    aw = V(awn);
    af = V(afn);
    piv = V(pn);
    // stretched laws g(a) = (a + 1e-4)^kappa - 1e-4^kappa
    gw = pow(max(aw, 0.0) + 1.0e-4, wk_kw) - pow(1.0e-4, wk_kw);
    dgw = wk_kw * pow(max(aw, 0.0) + 1.0e-4, wk_kw - 1.0);
    uw = exp(-gw);                               // unwoken fraction 1 - W (E14)
    gf = pow(max(af, 0.0) + 1.0e-4, fat_kf) - pow(1.0e-4, fat_kf);
    dgf = fat_kf * pow(max(af, 0.0) + 1.0e-4, fat_kf - 1.0);
    ef = exp(-gf);
    dmg = fat_d * (1.0 - ef);                    // fatigue damage D (E15)
    ddm = fat_d * ef * dgf;
    fw = wk_fp * uw;
    // (E18) reversible depinning pool: pinned part f_q (1 - Z), Z = mean z_j
    enq = 0.0;
    if (wk_fq > 0.0) enq = 1.0;
    zb = 0.0;
    for (i = 1; i <= `FE_NQ; i = i + 1) zb = zb + V(dqn[i]);
    zb = enq * zb / `FE_NQ;
    gq = 1.0 - wk_fq * (1.0 - zb);
    fpn = 1.0 - (1.0 - fw) * gq * (1.0 - dmg);   // pinned fraction f (E16, E18)
    dfaw = -gq * (1.0 - dmg) * wk_fp * uw * dgw;
    dfaf = gq * (1.0 - fw) * ddm;
    dfz = -wk_fq * (1.0 - fw) * (1.0 - dmg);
    sI = 0.0;
    for (i = 1; i <= `FE_NI; i = i + 1) sI = sI + V(imn[i]);
    sI = eni * sI / `FE_NI;
    vimpe = vimp - imp_v * sI;                   // dynamic imprint voltage (E17)
    // (E17a) both switching fields move outward by w = kappa_I V_I (sqrt(sI^2 + 1e-6) - 1e-3)
    wi = eni * imp_kw * imp_v * (sqrt(sI * sI + 1.0e-6) - 1.0e-3);
    // (E17b) field acceleration of the imprint rates, cosh(rho V / V_a) (argument capped at 80)
    gacc = 1.0;
    if (imp_va > 0.0) gacc = cosh(min(abs(rho * v) / imp_va, 80.0));
    me = 1.0 + fat_ke * dmg;

    // rate cut-off: exp(-z^-alpha) < exp(-60) is treated as exactly 0
    zmin = pow(60.0, -1.0 / alpha);
    // reversal threshold u_x = |V_imp| + 0.1 V (holding at 0 V is not a reversal)
    ux = abs(vimpe) + 0.1;
    // gated relaxation of h:  1/tau_h_eff = 1 / (tau_h [1 + ((V - V_imp)/0.1 V)^4])
    zv = (v - vimpe) / 0.1;
    relax = 1.0 / (tau_h * (1.0 + zv * zv * zv * zv));

    // (E4, E5) logit quantile grid y_j = y_max sinh(a xi_j)/sinh(a), weights
    // w_k = q_hi - q_lo, and the mean state x = sum_k w_k s_k
    x = 0.0;
    for (i = 1; i <= `FE_ND; i = i + 1) begin
        yl = y_max * sinh(grid_a * (2.0 * (i - 1) / `FE_ND - 1.0)) / sinh(grid_a);
        yh = y_max * sinh(grid_a * (2.0 * i / `FE_ND - 1.0)) / sinh(grid_a);
        ql = 1.0 / (1.0 + exp(-yl));
        qh = 1.0 / (1.0 + exp(-yh));
        if (i == 1) ql = 0.0;
        if (i == `FE_ND) qh = 1.0;
        x = x + (qh - ql) * V(sn[i]);
    end
    // total polarization state in units of Ps: switchable part plus pinned pool
    xt = (1.0 - fpn) * x + piv;

    rm = 0.0;
    act = 0.0;
    for (i = 1; i <= `FE_ND; i = i + 1) begin
        // (E4) activation voltage of class k from the Dagum quantile at the
        // mid-point q_k: E(q) = b [q^(-1/p) - 1]^(-1/a), times t_fe
        yl = y_max * sinh(grid_a * (2.0 * (i - 1) / `FE_ND - 1.0)) / sinh(grid_a);
        yh = y_max * sinh(grid_a * (2.0 * i / `FE_ND - 1.0)) / sinh(grid_a);
        qm_k = 1.0 / (1.0 + exp(-0.5 * (yl + yh)));
        ql = 1.0 / (1.0 + exp(-yl));
        qh = 1.0 / (1.0 + exp(-yh));
        if (i == 1) ql = 0.0;
        if (i == `FE_ND) qh = 1.0;
        vp = emp * te * me * pow(pow(qm_k, -1.0 / pt) - 1.0, -1.0 / ap);
        vn = emn * te * me * pow(pow(qm_k, -1.0 / pt) - 1.0, -1.0 / an);
        // optional per-class offset delta_k = sb * logit(frac(k * golden ratio))
        dl = 0.0;
        if (sb > 0.0) begin
            phi = i * 0.6180339887498949;
            phi = phi - floor(phi);
            phi = min(max(phi, 1.0e-3), 1.0 - 1.0e-3);
            dl = sb * ln(phi / (1.0 - phi));
        end
        // (E14) pristine internal-bias split: +V_sp on odd, -V_sp on even classes
        sgn = 1.0;
        if (i - 2 * floor(i / 2.0) < 0.5) sgn = -1.0;
        dl = dl + sgn * wk_vsp * uw;
        // (E1) drive seen by class k
        u = rho * v - vdep * (xt - sg) - vimpe - dl;
        // (E2) one-directional Merz-type rates R+ (u > 0) and R- (u < 0)
        rp = 0.0;
        rn = 0.0;
        if (u - wi > vp * zmin) rp = exp(-pow(vp / (u - wi), alpha)) / tau;
        if (-u - wi > vn * zmin) rn = exp(-pow(vn / (-u - wi), alpha)) / tau;
        s = V(sn[i]);
        h = V(hn[i]);
        hu = max(h, 0.0);
        hd = max(-h, 0.0);
        // saturation (h/h_m)^4 with h_m = 5, argument capped at 6
        cu = min(hu, 6.0) / 5.0;
        cu = cu * cu * cu * cu;
        cd = min(hd, 6.0) / 5.0;
        cd = cd * cd * cd * cd;
        // (E3) hazard r = beta R h^(beta-1); h^(beta-1) is linear below 1e-6
        ru = rp;
        rd = rn;
        if (beta > 1.0) begin
            ru = beta * rp * hu / max(hu, 1.0e-6) * exp((beta - 1.0) * ln(max(hu, 1.0e-6)));
            rd = beta * rn * hd / max(hd, 1.0e-6) * exp((beta - 1.0) * ln(max(hd, 1.0e-6)));
        end
        ds = ru * (1.0 - s) - rd * (1.0 + s);
        act = act + (qh - ql) * abs(ds);
        // (E3b) progress variable: growth, saturation, gated relaxation and the
        // reset term G(u - u_x) h- - G(-u - u_x) h+ with G(z) = [1 + tanh(z/10 mV)]/2,
        // tau_x = 0.1 ns
        gp = 0.5 * (1.0 + tanh((u - ux) / 0.01));
        gm_ = 0.5 * (1.0 + tanh((-u - ux) / 0.01));
        rev = (gp * hd - gm_ * hu) / 1.0e-10;
        dh = rp * (1.0 - cu) - rn * (1.0 - cd) - relax * h + rev;
        // step-size guard: |dX| <= bnd per step; while a reset is in progress
        // keep dt <= bnd * 2 tau_x so a non-L-stable method cannot ring
        rm = max(rm, max(ru * (1.0 - s) + rd * (1.0 + s), abs(dh)));
        // (with the dynamic imprint on, gate tails below 1e-6 are not counted as a reset:
        // the zero-field point then moves away from 0 V and h relaxes slowly there)
        if (gp * hd + gm_ * hu > 1.0e-9 && (eni < 0.5 || max(gp, gm_) > 1.0e-6)) rm = max(rm, bnd / 2.0e-10);
        // ddt() is unconditional so its history at t = 0 comes from the DC solution
        I(sn[i]) <+ `FE_TC * (ddt(V(sn[i])) + kst * 1.0e3 * (V(sn[i]) - s0) - (1.0 - kst) * ds);
        I(hn[i]) <+ `FE_TC * (ddt(V(hn[i])) + kst * 1.0e3 * V(hn[i]) - (1.0 - kst) * dh);
    end

    // (E14, E15) wake-up and fatigue ages; (E13) pinned pool: pinning takes the
    // mean state x with it, release returns the mean state pi/f of the pool to every class
    daw = enw * act / (4.0 * wk_nw) * exp(-wk_ea / `FE_KQ * (1.0 / tk - 1.0 / t0));
    efl = sqrt(rho * rho * v * v / (tfe * tfe) + 1.0e6);
    fff = pow(efl / 1.0e8, fat_nf);
    rtf = 0.0;
    if (fat_tf > 0.0) rtf = 1.0 / fat_tf;
    rns = 0.0;
    if (fat_ns > 0.0) rns = act / (4.0 * fat_ns);
    // (E19) optional build-up of the field-time stress: E_s^2 = max(E E_L, 0) + E_fl^2, E_L low-passed (t_L)
    enl = 0.0;
    if (enf > 0.5 && fat_tl > 0.0 && fat_tf > 0.0) enl = 1.0;
    vlf = V(fln);
    if (enl > 0.5) begin
        efll = sqrt(max(rho * rho * v * vlf / (tfe * tfe), 0.0) + 1.0e6);
        fffl = pow(efll / 1.0e8, fat_nf);
        daf = enf * (fffl * rtf + fff * rns) * exp(-fat_ea / `FE_KQ * (1.0 / tk - 1.0 / t0));
        rm = max(rm, abs(v - vlf) / fat_tl);
    end else
        daf = enf * fff * (rtf + rns) * exp(-fat_ea / `FE_KQ * (1.0 / tk - 1.0 / t0));
    I(fln) <+ `FE_TC * (ddt(V(fln)) + kst * 1.0e3 * (V(fln) - enl * v) - (1.0 - kst) * enl * (v - vlf) / max(fat_tl, 1.0e-30));
    fdot = dfaw * daw + dfaf * daf;
    // (E18) depinning states: tau_j dz_j/dt = A_w(T) [phi(V) (1 - z_j) - (rho_q + t_r act/4) z_j],
    // phi = (E_s/1 MV/cm)^n_q, act = sum_k w_k |ds_k/dt|
    phq = pow(efl / 1.0e8, wk_nq) - pow(1.0e-5, wk_nq);   // exactly 0 at 0 V
    arq = exp(-wk_ea / `FE_KQ * (1.0 / tk - 1.0 / t0));
    dzb = 0.0;
    for (i = 1; i <= `FE_NQ; i = i + 1) begin
        tq = exp(ln(wk_q1) + (i - 0.5) * (ln(wk_q2) - ln(wk_q1)) / `FE_NQ) / arq;
        dzq = enq * (phq * (1.0 - V(dqn[i])) - (wk_rho + wk_tr * act / 4.0) * V(dqn[i])) / tq;
        dzb = dzb + dzq / `FE_NQ;
        rm = max(rm, abs(dzq));
        I(dqn[i]) <+ `FE_TC * (ddt(V(dqn[i])) + kst * 1.0e3 * (V(dqn[i]) - enq * zq0) - (1.0 - kst) * dzq);
    end
    fdot = fdot + enq * dfz * dzb;
    fpin = max(fdot, 0.0);
    frel = max(-fdot, 0.0);
    ratio = min(max(piv / max(fpn, 1.0e-12), -1.0), 1.0);
    for (i = 1; i <= `FE_ND; i = i + 1)
        I(sn[i]) <+ -`FE_TC * (1.0 - kst) * frel * (ratio - V(sn[i])) / (1.0 - fpn);
    I(pn) <+ `FE_TC * (ddt(V(pn)) + kst * 1.0e3 * (V(pn) - fpn * s0) - (1.0 - kst) * (fpin * x - frel * ratio));
    I(awn) <+ `FE_TC * (ddt(V(awn)) + kst * 1.0e3 * (V(awn) - enw * nw0 / wk_nw) - (1.0 - kst) * daw);
    I(afn) <+ `FE_TC * (ddt(V(afn)) + kst * 1.0e3 * (V(afn) - enf * af0) - (1.0 - kst) * daf);
    // (E17) imprint states: log-spaced, thermally activated time constants
    ar_i = exp(imp_ea / `FE_KQ * (1.0 / tk - 1.0 / t0));
    for (i = 1; i <= `FE_NI; i = i + 1) begin
        tauj = exp(ln(imp_t1) + (i - 0.5) * (ln(imp_t2) - ln(imp_t1)) / `FE_NI) * ar_i;
        rm = max(rm, eni * gacc * abs(xt - V(imn[i])) / tauj);
        I(imn[i]) <+ `FE_TC * (ddt(V(imn[i])) + kst * 1.0e3 * (V(imn[i]) - eni * si0)
            - (1.0 - kst) * eni * gacc * (xt - V(imn[i])) / tauj);
    end
    if (rm > 1.0) $bound_step(bnd / rm);

    // (E7) low-pass voltage y and (E12) screening state sigma
    I(yn) <+ `FE_TC * (ddt(V(yn)) + kst * 1.0e3 * (V(yn) - v) - (1.0 - kst) * (v - yv) / tau_r);
    I(gn) <+ `FE_TC * (ddt(V(gn)) + kst * 1.0e3 * (V(gn) - s0 * sg0) - (1.0 - kst) * (xt - sg) / tau_s);

    // (E6) reversible charge.  Two arctan branches (integrated Lorentzians):
    // up-polarized domains follow g_up (peak at V_i - V_s), down-polarized ones
    // g_dn (peak at V_i + V_s).  Summed over classes this is gbar + x g_d.
    // the imprint bias moves both branches with the switching fields (E17)
    // and (E17a) their peaks move outward with the switching fields
    vie = vi - imp_v * sI / rho;
    vse = vs + wi / rho;
    gu = dcap * vw * (atan((v - vie + vse) / vw) - atan((-vie + vse) / vw));
    gd = dcap * vw * (atan((v - vie - vse) / vw) - atan((-vie - vse) / vw));
    guy = dcap * vw * (atan((yv - vie + vse) / vw) - atan((-vie + vse) / vw));
    gdy = dcap * vw * (atan((yv - vie - vse) / vw) - atan((-vie - vse) / vw));
    // term (2) is split as a whole into an instantaneous part (frev) and a
    // low-pass part (1 - frev): both have positive capacitance -> passive
    gb = frev * (gu + gd) + (1.0 - frev) * (guy + gdy);
    gmm = frev * (gu - gd) + (1.0 - frev) * (guy - gdy);
    // (E5, E6, E13) terminal charge density P + q_rev [C/m^2]; pinned domains keep
    // their polarization (pi) and their reversible displacement at the time of
    // pinning (r), and no longer follow the branches
    t2 = kc * 0.5 * (gb + x * gmm);
    I(prn) <+ `FE_TC * (ddt(V(prn)) + kst * 1.0e3 * (V(prn) - fpn * t2)
        - (1.0 - kst) * (fpin * t2 - frel * V(prn) / max(fpn, 1.0e-12)));
    qt = ptc * xt + kc * (c_d * v + 0.5 * (1.0 - fpn) * (gb + x * gmm)) + V(prn) + (c_w * (1.0 - x * x) + c_r) * yv;
    V(qm) <+ qt * 100.0;

    // (E9) leakage, one parameter set per polarity:
    // J = G v + tanh(v/V_th) [ PF + Schottky + TAT ]
    if (v >= 0.0) begin
        spf = spf_p; phit = phit_p; js = js_p; phib = phib_p; jt = jt_p; et = et_p;
    end else begin
        spf = spf_n; phit = phit_n; js = js_n; phib = phib_n; jt = jt_n; et = et_n;
    end
    es = sqrt(v * v / (tfe * tfe) + e0_leak * e0_leak);
    eroot = sqrt(es) - sqrt(e0_leak);
    ar = 1.0 / vth0 - 1.0 / vth;
    jl = g_oh * v * exp(phi_oh * ar);
    jl = jl + tanh(v / vth) * (spf * es * exp(phit * ar) * exp(min(2.0 * `FE_BS / sqrt(eps_op) * eroot / vth, 80.0))
        + js * (tk / t0) * (tk / t0) * exp(phib * ar) * (exp(min(`FE_BS / sqrt(eps_op) * eroot / vth, 80.0)) - 1.0)
        + jt * exp(-et / es));
    // (E20) leakage increase with the fatigue age (generated defects)
    if (fat_lk > 0.0) begin
        lkf = 1.0 + fat_lk * pow(max(af, 1.0e-30), fat_lm);
        jl = jl * lkf;
    end

    // (E8) terminal current
    I(p, n) <+ area * (ddt(qt) + jl);
end
endmodule
