* Leakage I-V by DC sweep at 25 C and 85 C
* Generated by spice/compare_ngspice.py --write-decks (do not edit by hand).
* Run from any directory:  ngspice_con -b leakage.cir
* It loads ../build/fecap_nls.osdi (python spice/build_osdi.py) and writes
* leakage.dat into the current working directory.
.include ../params/generic.inc
.temp 25
.options method=gear reltol=1e-4

* leakage currents are ~1e-16-1e-10 A: tighten the absolute current tolerance
.options abstol=1e-20 gmin=1e-25
* DC sweep
N1 p1 0 q1 fecap_generic s0=-1 area=1e-10
V1 p1 0 pwl(0 0 1 0)
.control
pre_osdi ../build/fecap_nls.osdi
set wr_singlescale
set wr_vecnames
set numdgt=15
dc V1 -3 3 0.05
wrdata leakage_25C.dat i(v1)
set temp = 85
option temp = 85
dc V1 -3 3 0.05
wrdata leakage_85C.dat i(v1)
.endc
.end
