* Triangular P-V loop at 100 kHz
* Generated by spice/compare_ngspice.py --write-decks (do not edit by hand).
* Run from any directory:  ngspice_con -b loop_100k.cir
* It loads ../build/fecap_nls.osdi (python spice/build_osdi.py) and writes
* loop_100k.dat into the current working directory.
.include ../params/generic.inc
.temp 25
.options method=gear reltol=1e-4

* triangular P-V loop, +-3 V, 100 kHz, from s0 = -1
N1 p1 0 q1 fecap_generic s0=-1 area=1e-10
V1 p1 0 pwl(0 0 2.5e-06 3 7.5e-06 -3 1.25e-05 3 1.75e-05 -3 2e-05 0)
.control
pre_osdi ../build/fecap_nls.osdi
set wr_singlescale
set wr_vecnames
set numdgt=15
tran 1.25e-09 2e-05
wrdata loop_100k.dat v(p1) v(q1) i(v1)
.endc
.end
