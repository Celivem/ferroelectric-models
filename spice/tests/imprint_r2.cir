* Imprint branch asymmetry and field acceleration (E17a, E17b)
* Generated by spice/compare_ngspice.py --write-decks (do not edit by hand).
* Run from any directory:  ngspice_con -b imprint_r2.cir
* It loads ../build/fecap_nls.osdi (python spice/build_osdi.py) and writes
* imprint_r2.dat into the current working directory.
.include ../params/generic.inc
.temp 25
.options method=gear reltol=1e-4

* the 50 ns imprint states, accelerated ~70x during the write: tighter step control
.options reltol=5e-6
* generic card with: imp_v=0.4 imp_t1=1e-07 imp_t2=0.01 imp_kw=0.3 imp_va=0.6
.model fecap_mod fecap_nls imp_v=0.4 imp_t1=1e-07 imp_t2=0.01 imp_kw=0.3 imp_va=0.6
* +3 V write, 1 ms at 0 V, -0.6 V read, -1.8 V and +1.8 V 5 us pulses; kappa_I and V_a on
N1 p1 0 q1 fecap_mod s0=-1 area=1e-10
V1 p1 0 pwl(0 0 5e-07 0 6e-07 3 1.6e-06 3 1.7e-06 0 0.0010017 0 0.0010018 -0.6 0.0010038 -0.6 0.0010039 0 0.0010239 0 0.001024 -1.8 0.001029 -1.8 0.0010291 0 0.0010791 0 0.0010792 1.8 0.0010842 1.8 0.0010843 0 0.0011343 0)
.control
pre_osdi ../build/fecap_nls.osdi
set wr_singlescale
set wr_vecnames
set numdgt=15
tran 2e-07 0.0011343
wrdata imprint_r2.dat v(p1) v(q1) i(v1)
.endc
.end
