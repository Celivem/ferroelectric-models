* Switched fraction vs pulse amplitude and width (24 instances)
* Generated by spice/compare_ngspice.py --write-decks (do not edit by hand).
* Run from any directory:  ngspice_con -b switching.cir
* It loads ../build/fecap_nls.osdi (python spice/build_osdi.py) and writes
* switching.dat into the current working directory.
.include ../params/generic.inc
.temp 25
.options method=gear reltol=1e-4

* 1.5 V, 0.1 us pulse from s0 = -1
N1 p1 0 q1 fecap_generic s0=-1 area=1e-10
V1 p1 0 pwl(0 0 1e-06 0 1.01e-06 1.5 1.11e-06 1.5 1.12e-06 0 3.3e-05 0)
* 1.5 V, 0.3 us pulse from s0 = -1
N2 p2 0 q2 fecap_generic s0=-1 area=1e-10
V2 p2 0 pwl(0 0 1e-06 0 1.01e-06 1.5 1.31e-06 1.5 1.32e-06 0 3.3e-05 0)
* 1.5 V, 1 us pulse from s0 = -1
N3 p3 0 q3 fecap_generic s0=-1 area=1e-10
V3 p3 0 pwl(0 0 1e-06 0 1.01e-06 1.5 2.01e-06 1.5 2.02e-06 0 3.3e-05 0)
* 1.5 V, 3 us pulse from s0 = -1
N4 p4 0 q4 fecap_generic s0=-1 area=1e-10
V4 p4 0 pwl(0 0 1e-06 0 1.01e-06 1.5 4.01e-06 1.5 4.02e-06 0 3.3e-05 0)
* 1.5 V, 10 us pulse from s0 = -1
N5 p5 0 q5 fecap_generic s0=-1 area=1e-10
V5 p5 0 pwl(0 0 1e-06 0 1.01e-06 1.5 1.101e-05 1.5 1.102e-05 0 3.3e-05 0)
* 1.5 V, 30 us pulse from s0 = -1
N6 p6 0 q6 fecap_generic s0=-1 area=1e-10
V6 p6 0 pwl(0 0 1e-06 0 1.01e-06 1.5 3.101e-05 1.5 3.102e-05 0 3.3e-05 0)
* 2.0 V, 0.1 us pulse from s0 = -1
N7 p7 0 q7 fecap_generic s0=-1 area=1e-10
V7 p7 0 pwl(0 0 1e-06 0 1.01e-06 2 1.11e-06 2 1.12e-06 0 3.3e-05 0)
* 2.0 V, 0.3 us pulse from s0 = -1
N8 p8 0 q8 fecap_generic s0=-1 area=1e-10
V8 p8 0 pwl(0 0 1e-06 0 1.01e-06 2 1.31e-06 2 1.32e-06 0 3.3e-05 0)
* 2.0 V, 1 us pulse from s0 = -1
N9 p9 0 q9 fecap_generic s0=-1 area=1e-10
V9 p9 0 pwl(0 0 1e-06 0 1.01e-06 2 2.01e-06 2 2.02e-06 0 3.3e-05 0)
* 2.0 V, 3 us pulse from s0 = -1
N10 p10 0 q10 fecap_generic s0=-1 area=1e-10
V10 p10 0 pwl(0 0 1e-06 0 1.01e-06 2 4.01e-06 2 4.02e-06 0 3.3e-05 0)
* 2.0 V, 10 us pulse from s0 = -1
N11 p11 0 q11 fecap_generic s0=-1 area=1e-10
V11 p11 0 pwl(0 0 1e-06 0 1.01e-06 2 1.101e-05 2 1.102e-05 0 3.3e-05 0)
* 2.0 V, 30 us pulse from s0 = -1
N12 p12 0 q12 fecap_generic s0=-1 area=1e-10
V12 p12 0 pwl(0 0 1e-06 0 1.01e-06 2 3.101e-05 2 3.102e-05 0 3.3e-05 0)
* 2.5 V, 0.1 us pulse from s0 = -1
N13 p13 0 q13 fecap_generic s0=-1 area=1e-10
V13 p13 0 pwl(0 0 1e-06 0 1.01e-06 2.5 1.11e-06 2.5 1.12e-06 0 3.3e-05 0)
* 2.5 V, 0.3 us pulse from s0 = -1
N14 p14 0 q14 fecap_generic s0=-1 area=1e-10
V14 p14 0 pwl(0 0 1e-06 0 1.01e-06 2.5 1.31e-06 2.5 1.32e-06 0 3.3e-05 0)
* 2.5 V, 1 us pulse from s0 = -1
N15 p15 0 q15 fecap_generic s0=-1 area=1e-10
V15 p15 0 pwl(0 0 1e-06 0 1.01e-06 2.5 2.01e-06 2.5 2.02e-06 0 3.3e-05 0)
* 2.5 V, 3 us pulse from s0 = -1
N16 p16 0 q16 fecap_generic s0=-1 area=1e-10
V16 p16 0 pwl(0 0 1e-06 0 1.01e-06 2.5 4.01e-06 2.5 4.02e-06 0 3.3e-05 0)
* 2.5 V, 10 us pulse from s0 = -1
N17 p17 0 q17 fecap_generic s0=-1 area=1e-10
V17 p17 0 pwl(0 0 1e-06 0 1.01e-06 2.5 1.101e-05 2.5 1.102e-05 0 3.3e-05 0)
* 2.5 V, 30 us pulse from s0 = -1
N18 p18 0 q18 fecap_generic s0=-1 area=1e-10
V18 p18 0 pwl(0 0 1e-06 0 1.01e-06 2.5 3.101e-05 2.5 3.102e-05 0 3.3e-05 0)
* 3.0 V, 0.1 us pulse from s0 = -1
N19 p19 0 q19 fecap_generic s0=-1 area=1e-10
V19 p19 0 pwl(0 0 1e-06 0 1.01e-06 3 1.11e-06 3 1.12e-06 0 3.3e-05 0)
* 3.0 V, 0.3 us pulse from s0 = -1
N20 p20 0 q20 fecap_generic s0=-1 area=1e-10
V20 p20 0 pwl(0 0 1e-06 0 1.01e-06 3 1.31e-06 3 1.32e-06 0 3.3e-05 0)
* 3.0 V, 1 us pulse from s0 = -1
N21 p21 0 q21 fecap_generic s0=-1 area=1e-10
V21 p21 0 pwl(0 0 1e-06 0 1.01e-06 3 2.01e-06 3 2.02e-06 0 3.3e-05 0)
* 3.0 V, 3 us pulse from s0 = -1
N22 p22 0 q22 fecap_generic s0=-1 area=1e-10
V22 p22 0 pwl(0 0 1e-06 0 1.01e-06 3 4.01e-06 3 4.02e-06 0 3.3e-05 0)
* 3.0 V, 10 us pulse from s0 = -1
N23 p23 0 q23 fecap_generic s0=-1 area=1e-10
V23 p23 0 pwl(0 0 1e-06 0 1.01e-06 3 1.101e-05 3 1.102e-05 0 3.3e-05 0)
* 3.0 V, 30 us pulse from s0 = -1
N24 p24 0 q24 fecap_generic s0=-1 area=1e-10
V24 p24 0 pwl(0 0 1e-06 0 1.01e-06 3 3.101e-05 3 3.102e-05 0 3.3e-05 0)
.control
pre_osdi ../build/fecap_nls.osdi
set wr_singlescale
set wr_vecnames
set numdgt=15
tran 5e-09 3.3e-05
wrdata switching.dat v(p1) v(q1) i(v1) v(p2) v(q2) i(v2) v(p3) v(q3) i(v3) v(p4) v(q4) i(v4) v(p5) v(q5) i(v5) v(p6) v(q6) i(v6) v(p7) v(q7) i(v7) v(p8) v(q8) i(v8) v(p9) v(q9) i(v9) v(p10) v(q10) i(v10) v(p11) v(q11) i(v11) v(p12) v(q12) i(v12) v(p13) v(q13) i(v13) v(p14) v(q14) i(v14) v(p15) v(q15) i(v15) v(p16) v(q16) i(v16) v(p17) v(q17) i(v17) v(p18) v(q18) i(v18) v(p19) v(q19) i(v19) v(p20) v(q20) i(v20) v(p21) v(q21) i(v21) v(p22) v(q22) i(v22) v(p23) v(q23) i(v23) v(p24) v(q24) i(v24)
.endc
.end
