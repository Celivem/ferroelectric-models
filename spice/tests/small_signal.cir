* 1000 cycles of a 1 MHz triangle
* Generated by spice/compare_ngspice.py --write-decks (do not edit by hand).
* Run from any directory:  ngspice_con -b small_signal.cir
* It loads ../build/fecap_nls.osdi (python spice/build_osdi.py) and writes
* small_signal.dat into the current working directory.
.include ../params/generic.inc
.temp 25
.options method=gear reltol=1e-4

* +-0.3 V from s0 = +1, 1000 cycles at 1 MHz
N1 p1 0 q1 fecap_generic s0=1 area=1e-10
V1 p1 0 pwl(0 0 5e-06 0 5.25e-06 -0.3 5.75e-06 0.3 6e-06 0 6.25e-06 -0.3 6.75e-06 0.3 7e-06 0 7.25e-06 -0.3 7.75e-06 0.3 8e-06 0 8.25e-06 -0.3 8.75e-06 0.3 9e-06 0 9.25e-06 -0.3 9.75e-06 0.3 1e-05 0 1.025e-05 -0.3 1.075e-05 0.3 1.1e-05 0 1.125e-05 -0.3 1.175e-05 0.3 1.2e-05 0 1.225e-05 -0.3 1.275e-05 0.3 1.3e-05 0 1.325e-05 -0.3 1.375e-05 0.3 1.4e-05 0 1.425e-05 -0.3 1.475e-05 0.3 1.5e-05 0 1.525e-05 -0.3 1.575e-05 0.3 1.6e-05 0 1.625e-05 -0.3 1.675e-05 0.3 1.7e-05 0 1.725e-05 -0.3 1.775e-05 0.3 1.8e-05 0 1.825e-05 -0.3 1.875e-05 0.3 1.9e-05 0 1.925e-05 -0.3 1.975e-05 0.3 2e-05 0 2.025e-05 -0.3 2.075e-05 0.3 2.1e-05 0 2.125e-05 -0.3 2.175e-05 0.3 2.2e-05 0 2.225e-05 -0.3 2.275e-05 0.3 2.3e-05 0 2.325e-05 -0.3 2.375e-05 0.3 2.4e-05 0 2.425e-05 -0.3 2.475e-05 0.3 2.5e-05 0 2.525e-05 -0.3 2.575e-05 0.3 2.6e-05 0 2.625e-05 -0.3 2.675e-05 0.3 2.7e-05 0 2.725e-05 -0.3 2.775e-05 0.3 2.8e-05 0 2.825e-05 -0.3 2.875e-05 0.3 2.9e-05 0 2.925e-05 -0.3 2.975e-05 0.3 3e-05 0 3.025e-05 -0.3 3.075e-05 0.3 3.1e-05 0 3.125e-05 -0.3 3.175e-05 0.3 3.2e-05 0 3.225e-05 -0.3 3.275e-05 0.3 3.3e-05 0 3.325e-05 -0.3 3.375e-05 0.3 3.4e-05 0 3.425e-05 -0.3 3.475e-05 0.3 3.5e-05 0 3.525e-05 -0.3 3.575e-05 0.3 3.6e-05 0 3.625e-05 -0.3 3.675e-05 0.3 3.7e-05 0 3.725e-05 -0.3 3.775e-05 0.3 3.8e-05 0 3.825e-05 -0.3 3.875e-05 0.3 3.9e-05 0 3.925e-05 -0.3 3.975e-05 0.3 4e-05 0 4.025e-05 -0.3 4.075e-05 0.3 4.1e-05 0 4.125e-05 -0.3 4.175e-05 0.3 4.2e-05 0 4.225e-05 -0.3 4.275e-05 0.3 4.3e-05 0 4.325e-05 -0.3 4.375e-05 0.3 4.4e-05 0 4.425e-05 -0.3 4.475e-05 0.3 4.5e-05 0 4.525e-05 -0.3 4.575e-05 0.3 4.6e-05 0 4.625e-05 -0.3 4.675e-05 0.3 4.7e-05 0 4.725e-05 -0.3 4.775e-05 0.3 4.8e-05 0 4.825e-05 -0.3 4.875e-05 0.3 4.9e-05 0 4.925e-05 -0.3 4.975e-05 0.3 5e-05 0 5.025e-05 -0.3 5.075e-05 0.3 5.1e-05 0 5.125e-05 -0.3 5.175e-05 0.3 5.2e-05 0 5.225e-05 -0.3 5.275e-05 0.3 5.3e-05 0 5.325e-05 -0.3 5.375e-05 0.3 5.4e-05 0 5.425e-05 -0.3 5.475e-05 0.3 5.5e-05 0 5.525e-05 -0.3 5.575e-05 0.3 5.6e-05 0 5.625e-05 -0.3 5.675e-05 0.3 5.7e-05 0 5.725e-05 -0.3 5.775e-05 0.3 5.8e-05 0 5.825e-05 -0.3 5.875e-05 0.3 5.9e-05 0 5.925e-05 -0.3 5.975e-05 0.3 6e-05 0 6.025e-05 -0.3 6.075e-05 0.3 6.1e-05 0 6.125e-05 -0.3 6.175e-05 0.3 6.2e-05 0 6.225e-05 -0.3 6.275e-05 0.3 6.3e-05 0 6.325e-05 -0.3 6.375e-05 0.3 6.4e-05 0 6.425e-05 -0.3 6.475e-05 0.3 6.5e-05 0 6.525e-05 -0.3 6.575e-05 0.3 6.6e-05 0 6.625e-05 -0.3 6.675e-05 0.3 6.7e-05 0 6.725e-05 -0.3 6.775e-05 0.3 6.8e-05 0 6.825e-05 -0.3 6.875e-05 0.3 6.9e-05 0 6.925e-05 -0.3 6.975e-05 0.3 7e-05 0 7.025e-05 -0.3 7.075e-05 0.3 7.1e-05 0 7.125e-05 -0.3 7.175e-05 0.3 7.2e-05 0 7.225e-05 -0.3 7.275e-05 0.3 7.3e-05 0 7.325e-05 -0.3 7.375e-05 0.3 7.4e-05 0 7.425e-05 -0.3 7.475e-05 0.3 7.5e-05 0 7.525e-05 -0.3 7.575e-05 0.3 7.6e-05 0 7.625e-05 -0.3 7.675e-05 0.3 7.7e-05 0 7.725e-05 -0.3 7.775e-05 0.3 7.8e-05 0 7.825e-05 -0.3 7.875e-05 0.3 7.9e-05 0 7.925e-05 -0.3 7.975e-05 0.3 8e-05 0 8.025e-05 -0.3 8.075e-05 0.3 8.1e-05 0 8.125e-05 -0.3 8.175e-05 0.3 8.2e-05 0 8.225e-05 -0.3 8.275e-05 0.3 8.3e-05 0 8.325e-05 -0.3 8.375e-05 0.3 8.4e-05 0 8.425e-05 -0.3 8.475e-05 0.3 8.5e-05 0 8.525e-05 -0.3 8.575e-05 0.3 8.6e-05 0 8.625e-05 -0.3 8.675e-05 0.3 8.7e-05 0 8.725e-05 -0.3 8.775e-05 0.3 8.8e-05 0 8.825e-05 -0.3 8.875e-05 0.3 8.9e-05 0 8.925e-05 -0.3 8.975e-05 0.3 9e-05 0 9.025e-05 -0.3 9.075e-05 0.3 9.1e-05 0 9.125e-05 -0.3 9.175e-05 0.3 9.2e-05 0 9.225e-05 -0.3 9.275e-05 0.3 9.3e-05 0 9.325e-05 -0.3 9.375e-05 0.3 9.4e-05 0 9.425e-05 -0.3 9.475e-05 0.3 9.5e-05 0 9.525e-05 -0.3 9.575e-05 0.3 9.6e-05 0 9.625e-05 -0.3 9.675e-05 0.3 9.7e-05 0 9.725e-05 -0.3 9.775e-05 0.3 9.8e-05 0 9.825e-05 -0.3 9.875e-05 0.3 9.9e-05 0 9.925e-05 -0.3 9.975e-05 0.3 0.0001 0 0.00010025 -0.3 0.00010075 0.3 0.000101 0 0.00010125 -0.3 0.00010175 0.3 0.000102 0 0.00010225 -0.3 0.00010275 0.3 0.000103 0 0.00010325 -0.3 0.00010375 0.3 0.000104 0 0.00010425 -0.3 0.00010475 0.3 0.000105 0 0.00010525 -0.3 0.00010575 0.3 0.000106 0 0.00010625 -0.3 0.00010675 0.3 0.000107 0 0.00010725 -0.3 0.00010775 0.3 0.000108 0 0.00010825 -0.3 0.00010875 0.3 0.000109 0 0.00010925 -0.3 0.00010975 0.3 0.00011 0 0.00011025 -0.3 0.00011075 0.3 0.000111 0 0.00011125 -0.3 0.00011175 0.3 0.000112 0 0.00011225 -0.3 0.00011275 0.3 0.000113 0 0.00011325 -0.3 0.00011375 0.3 0.000114 0 0.00011425 -0.3 0.00011475 0.3 0.000115 0 0.00011525 -0.3 0.00011575 0.3 0.000116 0 0.00011625 -0.3 0.00011675 0.3 0.000117 0 0.00011725 -0.3 0.00011775 0.3 0.000118 0 0.00011825 -0.3 0.00011875 0.3 0.000119 0 0.00011925 -0.3 0.00011975 0.3 0.00012 0 0.00012025 -0.3 0.00012075 0.3 0.000121 0 0.00012125 -0.3 0.00012175 0.3 0.000122 0 0.00012225 -0.3 0.00012275 0.3 0.000123 0 0.00012325 -0.3 0.00012375 0.3 0.000124 0 0.00012425 -0.3 0.00012475 0.3 0.000125 0 0.00012525 -0.3 0.00012575 0.3 0.000126 0 0.00012625 -0.3 0.00012675 0.3 0.000127 0 0.00012725 -0.3 0.00012775 0.3 0.000128 0 0.00012825 -0.3 0.00012875 0.3 0.000129 0 0.00012925 -0.3 0.00012975 0.3 0.00013 0 0.00013025 -0.3 0.00013075 0.3 0.000131 0 0.00013125 -0.3 0.00013175 0.3 0.000132 0 0.00013225 -0.3 0.00013275 0.3 0.000133 0 0.00013325 -0.3 0.00013375 0.3 0.000134 0 0.00013425 -0.3 0.00013475 0.3 0.000135 0 0.00013525 -0.3 0.00013575 0.3 0.000136 0 0.00013625 -0.3 0.00013675 0.3 0.000137 0 0.00013725 -0.3 0.00013775 0.3 0.000138 0 0.00013825 -0.3 0.00013875 0.3 0.000139 0 0.00013925 -0.3 0.00013975 0.3 0.00014 0 0.00014025 -0.3 0.00014075 0.3 0.000141 0 0.00014125 -0.3 0.00014175 0.3 0.000142 0 0.00014225 -0.3 0.00014275 0.3 0.000143 0 0.00014325 -0.3 0.00014375 0.3 0.000144 0 0.00014425 -0.3 0.00014475 0.3 0.000145 0 0.00014525 -0.3 0.00014575 0.3 0.000146 0 0.00014625 -0.3 0.00014675 0.3 0.000147 0 0.00014725 -0.3 0.00014775 0.3 0.000148 0 0.00014825 -0.3 0.00014875 0.3 0.000149 0 0.00014925 -0.3 0.00014975 0.3 0.00015 0 0.00015025 -0.3 0.00015075 0.3 0.000151 0 0.00015125 -0.3 0.00015175 0.3 0.000152 0 0.00015225 -0.3 0.00015275 0.3 0.000153 0 0.00015325 -0.3 0.00015375 0.3 0.000154 0 0.00015425 -0.3 0.00015475 0.3 0.000155 0 0.00015525 -0.3 0.00015575 0.3 0.000156 0 0.00015625 -0.3 0.00015675 0.3 0.000157 0 0.00015725 -0.3 0.00015775 0.3 0.000158 0 0.00015825 -0.3 0.00015875 0.3 0.000159 0 0.00015925 -0.3 0.00015975 0.3 0.00016 0 0.00016025 -0.3 0.00016075 0.3 0.000161 0 0.00016125 -0.3 0.00016175 0.3 0.000162 0 0.00016225 -0.3 0.00016275 0.3 0.000163 0 0.00016325 -0.3 0.00016375 0.3 0.000164 0 0.00016425 -0.3 0.00016475 0.3 0.000165 0 0.00016525 -0.3 0.00016575 0.3 0.000166 0 0.00016625 -0.3 0.00016675 0.3 0.000167 0 0.00016725 -0.3 0.00016775 0.3 0.000168 0 0.00016825 -0.3 0.00016875 0.3 0.000169 0 0.00016925 -0.3 0.00016975 0.3 0.00017 0 0.00017025 -0.3 0.00017075 0.3 0.000171 0 0.00017125 -0.3 0.00017175 0.3 0.000172 0 0.00017225 -0.3 0.00017275 0.3 0.000173 0 0.00017325 -0.3 0.00017375 0.3 0.000174 0 0.00017425 -0.3 0.00017475 0.3 0.000175 0 0.00017525 -0.3 0.00017575 0.3 0.000176 0 0.00017625 -0.3 0.00017675 0.3 0.000177 0 0.00017725 -0.3 0.00017775 0.3 0.000178 0 0.00017825 -0.3 0.00017875 0.3 0.000179 0 0.00017925 -0.3 0.00017975 0.3 0.00018 0 0.00018025 -0.3 0.00018075 0.3 0.000181 0 0.00018125 -0.3 0.00018175 0.3 0.000182 0 0.00018225 -0.3 0.00018275 0.3 0.000183 0 0.00018325 -0.3 0.00018375 0.3 0.000184 0 0.00018425 -0.3 0.00018475 0.3 0.000185 0 0.00018525 -0.3 0.00018575 0.3 0.000186 0 0.00018625 -0.3 0.00018675 0.3 0.000187 0 0.00018725 -0.3 0.00018775 0.3 0.000188 0 0.00018825 -0.3 0.00018875 0.3 0.000189 0 0.00018925 -0.3 0.00018975 0.3 0.00019 0 0.00019025 -0.3 0.00019075 0.3 0.000191 0 0.00019125 -0.3 0.00019175 0.3 0.000192 0 0.00019225 -0.3 0.00019275 0.3 0.000193 0 0.00019325 -0.3 0.00019375 0.3 0.000194 0 0.00019425 -0.3 0.00019475 0.3 0.000195 0 0.00019525 -0.3 0.00019575 0.3 0.000196 0 0.00019625 -0.3 0.00019675 0.3 0.000197 0 0.00019725 -0.3 0.00019775 0.3 0.000198 0 0.00019825 -0.3 0.00019875 0.3 0.000199 0 0.00019925 -0.3 0.00019975 0.3 0.0002 0 0.00020025 -0.3 0.00020075 0.3 0.000201 0 0.00020125 -0.3 0.00020175 0.3 0.000202 0 0.00020225 -0.3 0.00020275 0.3 0.000203 0 0.00020325 -0.3 0.00020375 0.3 0.000204 0 0.00020425 -0.3 0.00020475 0.3 0.000205 0 0.00020525 -0.3 0.00020575 0.3 0.000206 0 0.00020625 -0.3 0.00020675 0.3 0.000207 0 0.00020725 -0.3 0.00020775 0.3 0.000208 0 0.00020825 -0.3 0.00020875 0.3 0.000209 0 0.00020925 -0.3 0.00020975 0.3 0.00021 0 0.00021025 -0.3 0.00021075 0.3 0.000211 0 0.00021125 -0.3 0.00021175 0.3 0.000212 0 0.00021225 -0.3 0.00021275 0.3 0.000213 0 0.00021325 -0.3 0.00021375 0.3 0.000214 0 0.00021425 -0.3 0.00021475 0.3 0.000215 0 0.00021525 -0.3 0.00021575 0.3 0.000216 0 0.00021625 -0.3 0.00021675 0.3 0.000217 0 0.00021725 -0.3 0.00021775 0.3 0.000218 0 0.00021825 -0.3 0.00021875 0.3 0.000219 0 0.00021925 -0.3 0.00021975 0.3 0.00022 0 0.00022025 -0.3 0.00022075 0.3 0.000221 0 0.00022125 -0.3 0.00022175 0.3 0.000222 0 0.00022225 -0.3 0.00022275 0.3 0.000223 0 0.00022325 -0.3 0.00022375 0.3 0.000224 0 0.00022425 -0.3 0.00022475 0.3 0.000225 0 0.00022525 -0.3 0.00022575 0.3 0.000226 0 0.00022625 -0.3 0.00022675 0.3 0.000227 0 0.00022725 -0.3 0.00022775 0.3 0.000228 0 0.00022825 -0.3 0.00022875 0.3 0.000229 0 0.00022925 -0.3 0.00022975 0.3 0.00023 0 0.00023025 -0.3 0.00023075 0.3 0.000231 0 0.00023125 -0.3 0.00023175 0.3 0.000232 0 0.00023225 -0.3 0.00023275 0.3 0.000233 0 0.00023325 -0.3 0.00023375 0.3 0.000234 0 0.00023425 -0.3 0.00023475 0.3 0.000235 0 0.00023525 -0.3 0.00023575 0.3 0.000236 0 0.00023625 -0.3 0.00023675 0.3 0.000237 0 0.00023725 -0.3 0.00023775 0.3 0.000238 0 0.00023825 -0.3 0.00023875 0.3 0.000239 0 0.00023925 -0.3 0.00023975 0.3 0.00024 0 0.00024025 -0.3 0.00024075 0.3 0.000241 0 0.00024125 -0.3 0.00024175 0.3 0.000242 0 0.00024225 -0.3 0.00024275 0.3 0.000243 0 0.00024325 -0.3 0.00024375 0.3 0.000244 0 0.00024425 -0.3 0.00024475 0.3 0.000245 0 0.00024525 -0.3 0.00024575 0.3 0.000246 0 0.00024625 -0.3 0.00024675 0.3 0.000247 0 0.00024725 -0.3 0.00024775 0.3 0.000248 0 0.00024825 -0.3 0.00024875 0.3 0.000249 0 0.00024925 -0.3 0.00024975 0.3 0.00025 0 0.00025025 -0.3 0.00025075 0.3 0.000251 0 0.00025125 -0.3 0.00025175 0.3 0.000252 0 0.00025225 -0.3 0.00025275 0.3 0.000253 0 0.00025325 -0.3 0.00025375 0.3 0.000254 0 0.00025425 -0.3 0.00025475 0.3 0.000255 0 0.00025525 -0.3 0.00025575 0.3 0.000256 0 0.00025625 -0.3 0.00025675 0.3 0.000257 0 0.00025725 -0.3 0.00025775 0.3 0.000258 0 0.00025825 -0.3 0.00025875 0.3 0.000259 0 0.00025925 -0.3 0.00025975 0.3 0.00026 0 0.00026025 -0.3 0.00026075 0.3 0.000261 0 0.00026125 -0.3 0.00026175 0.3 0.000262 0 0.00026225 -0.3 0.00026275 0.3 0.000263 0 0.00026325 -0.3 0.00026375 0.3 0.000264 0 0.00026425 -0.3 0.00026475 0.3 0.000265 0 0.00026525 -0.3 0.00026575 0.3 0.000266 0 0.00026625 -0.3 0.00026675 0.3 0.000267 0 0.00026725 -0.3 0.00026775 0.3 0.000268 0 0.00026825 -0.3 0.00026875 0.3 0.000269 0 0.00026925 -0.3 0.00026975 0.3 0.00027 0 0.00027025 -0.3 0.00027075 0.3 0.000271 0 0.00027125 -0.3 0.00027175 0.3 0.000272 0 0.00027225 -0.3 0.00027275 0.3 0.000273 0 0.00027325 -0.3 0.00027375 0.3 0.000274 0 0.00027425 -0.3 0.00027475 0.3 0.000275 0 0.00027525 -0.3 0.00027575 0.3 0.000276 0 0.00027625 -0.3 0.00027675 0.3 0.000277 0 0.00027725 -0.3 0.00027775 0.3 0.000278 0 0.00027825 -0.3 0.00027875 0.3 0.000279 0 0.00027925 -0.3 0.00027975 0.3 0.00028 0 0.00028025 -0.3 0.00028075 0.3 0.000281 0 0.00028125 -0.3 0.00028175 0.3 0.000282 0 0.00028225 -0.3 0.00028275 0.3 0.000283 0 0.00028325 -0.3 0.00028375 0.3 0.000284 0 0.00028425 -0.3 0.00028475 0.3 0.000285 0 0.00028525 -0.3 0.00028575 0.3 0.000286 0 0.00028625 -0.3 0.00028675 0.3 0.000287 0 0.00028725 -0.3 0.00028775 0.3 0.000288 0 0.00028825 -0.3 0.00028875 0.3 0.000289 0 0.00028925 -0.3 0.00028975 0.3 0.00029 0 0.00029025 -0.3 0.00029075 0.3 0.000291 0 0.00029125 -0.3 0.00029175 0.3 0.000292 0 0.00029225 -0.3 0.00029275 0.3 0.000293 0 0.00029325 -0.3 0.00029375 0.3 0.000294 0 0.00029425 -0.3 0.00029475 0.3 0.000295 0 0.00029525 -0.3 0.00029575 0.3 0.000296 0 0.00029625 -0.3 0.00029675 0.3 0.000297 0 0.00029725 -0.3 0.00029775 0.3 0.000298 0 0.00029825 -0.3 0.00029875 0.3 0.000299 0 0.00029925 -0.3 0.00029975 0.3 0.0003 0 0.00030025 -0.3 0.00030075 0.3 0.000301 0 0.00030125 -0.3 0.00030175 0.3 0.000302 0 0.00030225 -0.3 0.00030275 0.3 0.000303 0 0.00030325 -0.3 0.00030375 0.3 0.000304 0 0.00030425 -0.3 0.00030475 0.3 0.000305 0 0.00030525 -0.3 0.00030575 0.3 0.000306 0 0.00030625 -0.3 0.00030675 0.3 0.000307 0 0.00030725 -0.3 0.00030775 0.3 0.000308 0 0.00030825 -0.3 0.00030875 0.3 0.000309 0 0.00030925 -0.3 0.00030975 0.3 0.00031 0 0.00031025 -0.3 0.00031075 0.3 0.000311 0 0.00031125 -0.3 0.00031175 0.3 0.000312 0 0.00031225 -0.3 0.00031275 0.3 0.000313 0 0.00031325 -0.3 0.00031375 0.3 0.000314 0 0.00031425 -0.3 0.00031475 0.3 0.000315 0 0.00031525 -0.3 0.00031575 0.3 0.000316 0 0.00031625 -0.3 0.00031675 0.3 0.000317 0 0.00031725 -0.3 0.00031775 0.3 0.000318 0 0.00031825 -0.3 0.00031875 0.3 0.000319 0 0.00031925 -0.3 0.00031975 0.3 0.00032 0 0.00032025 -0.3 0.00032075 0.3 0.000321 0 0.00032125 -0.3 0.00032175 0.3 0.000322 0 0.00032225 -0.3 0.00032275 0.3 0.000323 0 0.00032325 -0.3 0.00032375 0.3 0.000324 0 0.00032425 -0.3 0.00032475 0.3 0.000325 0 0.00032525 -0.3 0.00032575 0.3 0.000326 0 0.00032625 -0.3 0.00032675 0.3 0.000327 0 0.00032725 -0.3 0.00032775 0.3 0.000328 0 0.00032825 -0.3 0.00032875 0.3 0.000329 0 0.00032925 -0.3 0.00032975 0.3 0.00033 0 0.00033025 -0.3 0.00033075 0.3 0.000331 0 0.00033125 -0.3 0.00033175 0.3 0.000332 0 0.00033225 -0.3 0.00033275 0.3 0.000333 0 0.00033325 -0.3 0.00033375 0.3 0.000334 0 0.00033425 -0.3 0.00033475 0.3 0.000335 0 0.00033525 -0.3 0.00033575 0.3 0.000336 0 0.00033625 -0.3 0.00033675 0.3 0.000337 0 0.00033725 -0.3 0.00033775 0.3 0.000338 0 0.00033825 -0.3 0.00033875 0.3 0.000339 0 0.00033925 -0.3 0.00033975 0.3 0.00034 0 0.00034025 -0.3 0.00034075 0.3 0.000341 0 0.00034125 -0.3 0.00034175 0.3 0.000342 0 0.00034225 -0.3 0.00034275 0.3 0.000343 0 0.00034325 -0.3 0.00034375 0.3 0.000344 0 0.00034425 -0.3 0.00034475 0.3 0.000345 0 0.00034525 -0.3 0.00034575 0.3 0.000346 0 0.00034625 -0.3 0.00034675 0.3 0.000347 0 0.00034725 -0.3 0.00034775 0.3 0.000348 0 0.00034825 -0.3 0.00034875 0.3 0.000349 0 0.00034925 -0.3 0.00034975 0.3 0.00035 0 0.00035025 -0.3 0.00035075 0.3 0.000351 0 0.00035125 -0.3 0.00035175 0.3 0.000352 0 0.00035225 -0.3 0.00035275 0.3 0.000353 0 0.00035325 -0.3 0.00035375 0.3 0.000354 0 0.00035425 -0.3 0.00035475 0.3 0.000355 0 0.00035525 -0.3 0.00035575 0.3 0.000356 0 0.00035625 -0.3 0.00035675 0.3 0.000357 0 0.00035725 -0.3 0.00035775 0.3 0.000358 0 0.00035825 -0.3 0.00035875 0.3 0.000359 0 0.00035925 -0.3 0.00035975 0.3 0.00036 0 0.00036025 -0.3 0.00036075 0.3 0.000361 0 0.00036125 -0.3 0.00036175 0.3 0.000362 0 0.00036225 -0.3 0.00036275 0.3 0.000363 0 0.00036325 -0.3 0.00036375 0.3 0.000364 0 0.00036425 -0.3 0.00036475 0.3 0.000365 0 0.00036525 -0.3 0.00036575 0.3 0.000366 0 0.00036625 -0.3 0.00036675 0.3 0.000367 0 0.00036725 -0.3 0.00036775 0.3 0.000368 0 0.00036825 -0.3 0.00036875 0.3 0.000369 0 0.00036925 -0.3 0.00036975 0.3 0.00037 0 0.00037025 -0.3 0.00037075 0.3 0.000371 0 0.00037125 -0.3 0.00037175 0.3 0.000372 0 0.00037225 -0.3 0.00037275 0.3 0.000373 0 0.00037325 -0.3 0.00037375 0.3 0.000374 0 0.00037425 -0.3 0.00037475 0.3 0.000375 0 0.00037525 -0.3 0.00037575 0.3 0.000376 0 0.00037625 -0.3 0.00037675 0.3 0.000377 0 0.00037725 -0.3 0.00037775 0.3 0.000378 0 0.00037825 -0.3 0.00037875 0.3 0.000379 0 0.00037925 -0.3 0.00037975 0.3 0.00038 0 0.00038025 -0.3 0.00038075 0.3 0.000381 0 0.00038125 -0.3 0.00038175 0.3 0.000382 0 0.00038225 -0.3 0.00038275 0.3 0.000383 0 0.00038325 -0.3 0.00038375 0.3 0.000384 0 0.00038425 -0.3 0.00038475 0.3 0.000385 0 0.00038525 -0.3 0.00038575 0.3 0.000386 0 0.00038625 -0.3 0.00038675 0.3 0.000387 0 0.00038725 -0.3 0.00038775 0.3 0.000388 0 0.00038825 -0.3 0.00038875 0.3 0.000389 0 0.00038925 -0.3 0.00038975 0.3 0.00039 0 0.00039025 -0.3 0.00039075 0.3 0.000391 0 0.00039125 -0.3 0.00039175 0.3 0.000392 0 0.00039225 -0.3 0.00039275 0.3 0.000393 0 0.00039325 -0.3 0.00039375 0.3 0.000394 0 0.00039425 -0.3 0.00039475 0.3 0.000395 0 0.00039525 -0.3 0.00039575 0.3 0.000396 0 0.00039625 -0.3 0.00039675 0.3 0.000397 0 0.00039725 -0.3 0.00039775 0.3 0.000398 0 0.00039825 -0.3 0.00039875 0.3 0.000399 0 0.00039925 -0.3 0.00039975 0.3 0.0004 0 0.00040025 -0.3 0.00040075 0.3 0.000401 0 0.00040125 -0.3 0.00040175 0.3 0.000402 0 0.00040225 -0.3 0.00040275 0.3 0.000403 0 0.00040325 -0.3 0.00040375 0.3 0.000404 0 0.00040425 -0.3 0.00040475 0.3 0.000405 0 0.00040525 -0.3 0.00040575 0.3 0.000406 0 0.00040625 -0.3 0.00040675 0.3 0.000407 0 0.00040725 -0.3 0.00040775 0.3 0.000408 0 0.00040825 -0.3 0.00040875 0.3 0.000409 0 0.00040925 -0.3 0.00040975 0.3 0.00041 0 0.00041025 -0.3 0.00041075 0.3 0.000411 0 0.00041125 -0.3 0.00041175 0.3 0.000412 0 0.00041225 -0.3 0.00041275 0.3 0.000413 0 0.00041325 -0.3 0.00041375 0.3 0.000414 0 0.00041425 -0.3 0.00041475 0.3 0.000415 0 0.00041525 -0.3 0.00041575 0.3 0.000416 0 0.00041625 -0.3 0.00041675 0.3 0.000417 0 0.00041725 -0.3 0.00041775 0.3 0.000418 0 0.00041825 -0.3 0.00041875 0.3 0.000419 0 0.00041925 -0.3 0.00041975 0.3 0.00042 0 0.00042025 -0.3 0.00042075 0.3 0.000421 0 0.00042125 -0.3 0.00042175 0.3 0.000422 0 0.00042225 -0.3 0.00042275 0.3 0.000423 0 0.00042325 -0.3 0.00042375 0.3 0.000424 0 0.00042425 -0.3 0.00042475 0.3 0.000425 0 0.00042525 -0.3 0.00042575 0.3 0.000426 0 0.00042625 -0.3 0.00042675 0.3 0.000427 0 0.00042725 -0.3 0.00042775 0.3 0.000428 0 0.00042825 -0.3 0.00042875 0.3 0.000429 0 0.00042925 -0.3 0.00042975 0.3 0.00043 0 0.00043025 -0.3 0.00043075 0.3 0.000431 0 0.00043125 -0.3 0.00043175 0.3 0.000432 0 0.00043225 -0.3 0.00043275 0.3 0.000433 0 0.00043325 -0.3 0.00043375 0.3 0.000434 0 0.00043425 -0.3 0.00043475 0.3 0.000435 0 0.00043525 -0.3 0.00043575 0.3 0.000436 0 0.00043625 -0.3 0.00043675 0.3 0.000437 0 0.00043725 -0.3 0.00043775 0.3 0.000438 0 0.00043825 -0.3 0.00043875 0.3 0.000439 0 0.00043925 -0.3 0.00043975 0.3 0.00044 0 0.00044025 -0.3 0.00044075 0.3 0.000441 0 0.00044125 -0.3 0.00044175 0.3 0.000442 0 0.00044225 -0.3 0.00044275 0.3 0.000443 0 0.00044325 -0.3 0.00044375 0.3 0.000444 0 0.00044425 -0.3 0.00044475 0.3 0.000445 0 0.00044525 -0.3 0.00044575 0.3 0.000446 0 0.00044625 -0.3 0.00044675 0.3 0.000447 0 0.00044725 -0.3 0.00044775 0.3 0.000448 0 0.00044825 -0.3 0.00044875 0.3 0.000449 0 0.00044925 -0.3 0.00044975 0.3 0.00045 0 0.00045025 -0.3 0.00045075 0.3 0.000451 0 0.00045125 -0.3 0.00045175 0.3 0.000452 0 0.00045225 -0.3 0.00045275 0.3 0.000453 0 0.00045325 -0.3 0.00045375 0.3 0.000454 0 0.00045425 -0.3 0.00045475 0.3 0.000455 0 0.00045525 -0.3 0.00045575 0.3 0.000456 0 0.00045625 -0.3 0.00045675 0.3 0.000457 0 0.00045725 -0.3 0.00045775 0.3 0.000458 0 0.00045825 -0.3 0.00045875 0.3 0.000459 0 0.00045925 -0.3 0.00045975 0.3 0.00046 0 0.00046025 -0.3 0.00046075 0.3 0.000461 0 0.00046125 -0.3 0.00046175 0.3 0.000462 0 0.00046225 -0.3 0.00046275 0.3 0.000463 0 0.00046325 -0.3 0.00046375 0.3 0.000464 0 0.00046425 -0.3 0.00046475 0.3 0.000465 0 0.00046525 -0.3 0.00046575 0.3 0.000466 0 0.00046625 -0.3 0.00046675 0.3 0.000467 0 0.00046725 -0.3 0.00046775 0.3 0.000468 0 0.00046825 -0.3 0.00046875 0.3 0.000469 0 0.00046925 -0.3 0.00046975 0.3 0.00047 0 0.00047025 -0.3 0.00047075 0.3 0.000471 0 0.00047125 -0.3 0.00047175 0.3 0.000472 0 0.00047225 -0.3 0.00047275 0.3 0.000473 0 0.00047325 -0.3 0.00047375 0.3 0.000474 0 0.00047425 -0.3 0.00047475 0.3 0.000475 0 0.00047525 -0.3 0.00047575 0.3 0.000476 0 0.00047625 -0.3 0.00047675 0.3 0.000477 0 0.00047725 -0.3 0.00047775 0.3 0.000478 0 0.00047825 -0.3 0.00047875 0.3 0.000479 0 0.00047925 -0.3 0.00047975 0.3 0.00048 0 0.00048025 -0.3 0.00048075 0.3 0.000481 0 0.00048125 -0.3 0.00048175 0.3 0.000482 0 0.00048225 -0.3 0.00048275 0.3 0.000483 0 0.00048325 -0.3 0.00048375 0.3 0.000484 0 0.00048425 -0.3 0.00048475 0.3 0.000485 0 0.00048525 -0.3 0.00048575 0.3 0.000486 0 0.00048625 -0.3 0.00048675 0.3 0.000487 0 0.00048725 -0.3 0.00048775 0.3 0.000488 0 0.00048825 -0.3 0.00048875 0.3 0.000489 0 0.00048925 -0.3 0.00048975 0.3 0.00049 0 0.00049025 -0.3 0.00049075 0.3 0.000491 0 0.00049125 -0.3 0.00049175 0.3 0.000492 0 0.00049225 -0.3 0.00049275 0.3 0.000493 0 0.00049325 -0.3 0.00049375 0.3 0.000494 0 0.00049425 -0.3 0.00049475 0.3 0.000495 0 0.00049525 -0.3 0.00049575 0.3 0.000496 0 0.00049625 -0.3 0.00049675 0.3 0.000497 0 0.00049725 -0.3 0.00049775 0.3 0.000498 0 0.00049825 -0.3 0.00049875 0.3 0.000499 0 0.00049925 -0.3 0.00049975 0.3 0.0005 0 0.00050025 -0.3 0.00050075 0.3 0.000501 0 0.00050125 -0.3 0.00050175 0.3 0.000502 0 0.00050225 -0.3 0.00050275 0.3 0.000503 0 0.00050325 -0.3 0.00050375 0.3 0.000504 0 0.00050425 -0.3 0.00050475 0.3 0.000505 0 0.00050525 -0.3 0.00050575 0.3 0.000506 0 0.00050625 -0.3 0.00050675 0.3 0.000507 0 0.00050725 -0.3 0.00050775 0.3 0.000508 0 0.00050825 -0.3 0.00050875 0.3 0.000509 0 0.00050925 -0.3 0.00050975 0.3 0.00051 0 0.00051025 -0.3 0.00051075 0.3 0.000511 0 0.00051125 -0.3 0.00051175 0.3 0.000512 0 0.00051225 -0.3 0.00051275 0.3 0.000513 0 0.00051325 -0.3 0.00051375 0.3 0.000514 0 0.00051425 -0.3 0.00051475 0.3 0.000515 0 0.00051525 -0.3 0.00051575 0.3 0.000516 0 0.00051625 -0.3 0.00051675 0.3 0.000517 0 0.00051725 -0.3 0.00051775 0.3 0.000518 0 0.00051825 -0.3 0.00051875 0.3 0.000519 0 0.00051925 -0.3 0.00051975 0.3 0.00052 0 0.00052025 -0.3 0.00052075 0.3 0.000521 0 0.00052125 -0.3 0.00052175 0.3 0.000522 0 0.00052225 -0.3 0.00052275 0.3 0.000523 0 0.00052325 -0.3 0.00052375 0.3 0.000524 0 0.00052425 -0.3 0.00052475 0.3 0.000525 0 0.00052525 -0.3 0.00052575 0.3 0.000526 0 0.00052625 -0.3 0.00052675 0.3 0.000527 0 0.00052725 -0.3 0.00052775 0.3 0.000528 0 0.00052825 -0.3 0.00052875 0.3 0.000529 0 0.00052925 -0.3 0.00052975 0.3 0.00053 0 0.00053025 -0.3 0.00053075 0.3 0.000531 0 0.00053125 -0.3 0.00053175 0.3 0.000532 0 0.00053225 -0.3 0.00053275 0.3 0.000533 0 0.00053325 -0.3 0.00053375 0.3 0.000534 0 0.00053425 -0.3 0.00053475 0.3 0.000535 0 0.00053525 -0.3 0.00053575 0.3 0.000536 0 0.00053625 -0.3 0.00053675 0.3 0.000537 0 0.00053725 -0.3 0.00053775 0.3 0.000538 0 0.00053825 -0.3 0.00053875 0.3 0.000539 0 0.00053925 -0.3 0.00053975 0.3 0.00054 0 0.00054025 -0.3 0.00054075 0.3 0.000541 0 0.00054125 -0.3 0.00054175 0.3 0.000542 0 0.00054225 -0.3 0.00054275 0.3 0.000543 0 0.00054325 -0.3 0.00054375 0.3 0.000544 0 0.00054425 -0.3 0.00054475 0.3 0.000545 0 0.00054525 -0.3 0.00054575 0.3 0.000546 0 0.00054625 -0.3 0.00054675 0.3 0.000547 0 0.00054725 -0.3 0.00054775 0.3 0.000548 0 0.00054825 -0.3 0.00054875 0.3 0.000549 0 0.00054925 -0.3 0.00054975 0.3 0.00055 0 0.00055025 -0.3 0.00055075 0.3 0.000551 0 0.00055125 -0.3 0.00055175 0.3 0.000552 0 0.00055225 -0.3 0.00055275 0.3 0.000553 0 0.00055325 -0.3 0.00055375 0.3 0.000554 0 0.00055425 -0.3 0.00055475 0.3 0.000555 0 0.00055525 -0.3 0.00055575 0.3 0.000556 0 0.00055625 -0.3 0.00055675 0.3 0.000557 0 0.00055725 -0.3 0.00055775 0.3 0.000558 0 0.00055825 -0.3 0.00055875 0.3 0.000559 0 0.00055925 -0.3 0.00055975 0.3 0.00056 0 0.00056025 -0.3 0.00056075 0.3 0.000561 0 0.00056125 -0.3 0.00056175 0.3 0.000562 0 0.00056225 -0.3 0.00056275 0.3 0.000563 0 0.00056325 -0.3 0.00056375 0.3 0.000564 0 0.00056425 -0.3 0.00056475 0.3 0.000565 0 0.00056525 -0.3 0.00056575 0.3 0.000566 0 0.00056625 -0.3 0.00056675 0.3 0.000567 0 0.00056725 -0.3 0.00056775 0.3 0.000568 0 0.00056825 -0.3 0.00056875 0.3 0.000569 0 0.00056925 -0.3 0.00056975 0.3 0.00057 0 0.00057025 -0.3 0.00057075 0.3 0.000571 0 0.00057125 -0.3 0.00057175 0.3 0.000572 0 0.00057225 -0.3 0.00057275 0.3 0.000573 0 0.00057325 -0.3 0.00057375 0.3 0.000574 0 0.00057425 -0.3 0.00057475 0.3 0.000575 0 0.00057525 -0.3 0.00057575 0.3 0.000576 0 0.00057625 -0.3 0.00057675 0.3 0.000577 0 0.00057725 -0.3 0.00057775 0.3 0.000578 0 0.00057825 -0.3 0.00057875 0.3 0.000579 0 0.00057925 -0.3 0.00057975 0.3 0.00058 0 0.00058025 -0.3 0.00058075 0.3 0.000581 0 0.00058125 -0.3 0.00058175 0.3 0.000582 0 0.00058225 -0.3 0.00058275 0.3 0.000583 0 0.00058325 -0.3 0.00058375 0.3 0.000584 0 0.00058425 -0.3 0.00058475 0.3 0.000585 0 0.00058525 -0.3 0.00058575 0.3 0.000586 0 0.00058625 -0.3 0.00058675 0.3 0.000587 0 0.00058725 -0.3 0.00058775 0.3 0.000588 0 0.00058825 -0.3 0.00058875 0.3 0.000589 0 0.00058925 -0.3 0.00058975 0.3 0.00059 0 0.00059025 -0.3 0.00059075 0.3 0.000591 0 0.00059125 -0.3 0.00059175 0.3 0.000592 0 0.00059225 -0.3 0.00059275 0.3 0.000593 0 0.00059325 -0.3 0.00059375 0.3 0.000594 0 0.00059425 -0.3 0.00059475 0.3 0.000595 0 0.00059525 -0.3 0.00059575 0.3 0.000596 0 0.00059625 -0.3 0.00059675 0.3 0.000597 0 0.00059725 -0.3 0.00059775 0.3 0.000598 0 0.00059825 -0.3 0.00059875 0.3 0.000599 0 0.00059925 -0.3 0.00059975 0.3 0.0006 0 0.00060025 -0.3 0.00060075 0.3 0.000601 0 0.00060125 -0.3 0.00060175 0.3 0.000602 0 0.00060225 -0.3 0.00060275 0.3 0.000603 0 0.00060325 -0.3 0.00060375 0.3 0.000604 0 0.00060425 -0.3 0.00060475 0.3 0.000605 0 0.00060525 -0.3 0.00060575 0.3 0.000606 0 0.00060625 -0.3 0.00060675 0.3 0.000607 0 0.00060725 -0.3 0.00060775 0.3 0.000608 0 0.00060825 -0.3 0.00060875 0.3 0.000609 0 0.00060925 -0.3 0.00060975 0.3 0.00061 0 0.00061025 -0.3 0.00061075 0.3 0.000611 0 0.00061125 -0.3 0.00061175 0.3 0.000612 0 0.00061225 -0.3 0.00061275 0.3 0.000613 0 0.00061325 -0.3 0.00061375 0.3 0.000614 0 0.00061425 -0.3 0.00061475 0.3 0.000615 0 0.00061525 -0.3 0.00061575 0.3 0.000616 0 0.00061625 -0.3 0.00061675 0.3 0.000617 0 0.00061725 -0.3 0.00061775 0.3 0.000618 0 0.00061825 -0.3 0.00061875 0.3 0.000619 0 0.00061925 -0.3 0.00061975 0.3 0.00062 0 0.00062025 -0.3 0.00062075 0.3 0.000621 0 0.00062125 -0.3 0.00062175 0.3 0.000622 0 0.00062225 -0.3 0.00062275 0.3 0.000623 0 0.00062325 -0.3 0.00062375 0.3 0.000624 0 0.00062425 -0.3 0.00062475 0.3 0.000625 0 0.00062525 -0.3 0.00062575 0.3 0.000626 0 0.00062625 -0.3 0.00062675 0.3 0.000627 0 0.00062725 -0.3 0.00062775 0.3 0.000628 0 0.00062825 -0.3 0.00062875 0.3 0.000629 0 0.00062925 -0.3 0.00062975 0.3 0.00063 0 0.00063025 -0.3 0.00063075 0.3 0.000631 0 0.00063125 -0.3 0.00063175 0.3 0.000632 0 0.00063225 -0.3 0.00063275 0.3 0.000633 0 0.00063325 -0.3 0.00063375 0.3 0.000634 0 0.00063425 -0.3 0.00063475 0.3 0.000635 0 0.00063525 -0.3 0.00063575 0.3 0.000636 0 0.00063625 -0.3 0.00063675 0.3 0.000637 0 0.00063725 -0.3 0.00063775 0.3 0.000638 0 0.00063825 -0.3 0.00063875 0.3 0.000639 0 0.00063925 -0.3 0.00063975 0.3 0.00064 0 0.00064025 -0.3 0.00064075 0.3 0.000641 0 0.00064125 -0.3 0.00064175 0.3 0.000642 0 0.00064225 -0.3 0.00064275 0.3 0.000643 0 0.00064325 -0.3 0.00064375 0.3 0.000644 0 0.00064425 -0.3 0.00064475 0.3 0.000645 0 0.00064525 -0.3 0.00064575 0.3 0.000646 0 0.00064625 -0.3 0.00064675 0.3 0.000647 0 0.00064725 -0.3 0.00064775 0.3 0.000648 0 0.00064825 -0.3 0.00064875 0.3 0.000649 0 0.00064925 -0.3 0.00064975 0.3 0.00065 0 0.00065025 -0.3 0.00065075 0.3 0.000651 0 0.00065125 -0.3 0.00065175 0.3 0.000652 0 0.00065225 -0.3 0.00065275 0.3 0.000653 0 0.00065325 -0.3 0.00065375 0.3 0.000654 0 0.00065425 -0.3 0.00065475 0.3 0.000655 0 0.00065525 -0.3 0.00065575 0.3 0.000656 0 0.00065625 -0.3 0.00065675 0.3 0.000657 0 0.00065725 -0.3 0.00065775 0.3 0.000658 0 0.00065825 -0.3 0.00065875 0.3 0.000659 0 0.00065925 -0.3 0.00065975 0.3 0.00066 0 0.00066025 -0.3 0.00066075 0.3 0.000661 0 0.00066125 -0.3 0.00066175 0.3 0.000662 0 0.00066225 -0.3 0.00066275 0.3 0.000663 0 0.00066325 -0.3 0.00066375 0.3 0.000664 0 0.00066425 -0.3 0.00066475 0.3 0.000665 0 0.00066525 -0.3 0.00066575 0.3 0.000666 0 0.00066625 -0.3 0.00066675 0.3 0.000667 0 0.00066725 -0.3 0.00066775 0.3 0.000668 0 0.00066825 -0.3 0.00066875 0.3 0.000669 0 0.00066925 -0.3 0.00066975 0.3 0.00067 0 0.00067025 -0.3 0.00067075 0.3 0.000671 0 0.00067125 -0.3 0.00067175 0.3 0.000672 0 0.00067225 -0.3 0.00067275 0.3 0.000673 0 0.00067325 -0.3 0.00067375 0.3 0.000674 0 0.00067425 -0.3 0.00067475 0.3 0.000675 0 0.00067525 -0.3 0.00067575 0.3 0.000676 0 0.00067625 -0.3 0.00067675 0.3 0.000677 0 0.00067725 -0.3 0.00067775 0.3 0.000678 0 0.00067825 -0.3 0.00067875 0.3 0.000679 0 0.00067925 -0.3 0.00067975 0.3 0.00068 0 0.00068025 -0.3 0.00068075 0.3 0.000681 0 0.00068125 -0.3 0.00068175 0.3 0.000682 0 0.00068225 -0.3 0.00068275 0.3 0.000683 0 0.00068325 -0.3 0.00068375 0.3 0.000684 0 0.00068425 -0.3 0.00068475 0.3 0.000685 0 0.00068525 -0.3 0.00068575 0.3 0.000686 0 0.00068625 -0.3 0.00068675 0.3 0.000687 0 0.00068725 -0.3 0.00068775 0.3 0.000688 0 0.00068825 -0.3 0.00068875 0.3 0.000689 0 0.00068925 -0.3 0.00068975 0.3 0.00069 0 0.00069025 -0.3 0.00069075 0.3 0.000691 0 0.00069125 -0.3 0.00069175 0.3 0.000692 0 0.00069225 -0.3 0.00069275 0.3 0.000693 0 0.00069325 -0.3 0.00069375 0.3 0.000694 0 0.00069425 -0.3 0.00069475 0.3 0.000695 0 0.00069525 -0.3 0.00069575 0.3 0.000696 0 0.00069625 -0.3 0.00069675 0.3 0.000697 0 0.00069725 -0.3 0.00069775 0.3 0.000698 0 0.00069825 -0.3 0.00069875 0.3 0.000699 0 0.00069925 -0.3 0.00069975 0.3 0.0007 0 0.00070025 -0.3 0.00070075 0.3 0.000701 0 0.00070125 -0.3 0.00070175 0.3 0.000702 0 0.00070225 -0.3 0.00070275 0.3 0.000703 0 0.00070325 -0.3 0.00070375 0.3 0.000704 0 0.00070425 -0.3 0.00070475 0.3 0.000705 0 0.00070525 -0.3 0.00070575 0.3 0.000706 0 0.00070625 -0.3 0.00070675 0.3 0.000707 0 0.00070725 -0.3 0.00070775 0.3 0.000708 0 0.00070825 -0.3 0.00070875 0.3 0.000709 0 0.00070925 -0.3 0.00070975 0.3 0.00071 0 0.00071025 -0.3 0.00071075 0.3 0.000711 0 0.00071125 -0.3 0.00071175 0.3 0.000712 0 0.00071225 -0.3 0.00071275 0.3 0.000713 0 0.00071325 -0.3 0.00071375 0.3 0.000714 0 0.00071425 -0.3 0.00071475 0.3 0.000715 0 0.00071525 -0.3 0.00071575 0.3 0.000716 0 0.00071625 -0.3 0.00071675 0.3 0.000717 0 0.00071725 -0.3 0.00071775 0.3 0.000718 0 0.00071825 -0.3 0.00071875 0.3 0.000719 0 0.00071925 -0.3 0.00071975 0.3 0.00072 0 0.00072025 -0.3 0.00072075 0.3 0.000721 0 0.00072125 -0.3 0.00072175 0.3 0.000722 0 0.00072225 -0.3 0.00072275 0.3 0.000723 0 0.00072325 -0.3 0.00072375 0.3 0.000724 0 0.00072425 -0.3 0.00072475 0.3 0.000725 0 0.00072525 -0.3 0.00072575 0.3 0.000726 0 0.00072625 -0.3 0.00072675 0.3 0.000727 0 0.00072725 -0.3 0.00072775 0.3 0.000728 0 0.00072825 -0.3 0.00072875 0.3 0.000729 0 0.00072925 -0.3 0.00072975 0.3 0.00073 0 0.00073025 -0.3 0.00073075 0.3 0.000731 0 0.00073125 -0.3 0.00073175 0.3 0.000732 0 0.00073225 -0.3 0.00073275 0.3 0.000733 0 0.00073325 -0.3 0.00073375 0.3 0.000734 0 0.00073425 -0.3 0.00073475 0.3 0.000735 0 0.00073525 -0.3 0.00073575 0.3 0.000736 0 0.00073625 -0.3 0.00073675 0.3 0.000737 0 0.00073725 -0.3 0.00073775 0.3 0.000738 0 0.00073825 -0.3 0.00073875 0.3 0.000739 0 0.00073925 -0.3 0.00073975 0.3 0.00074 0 0.00074025 -0.3 0.00074075 0.3 0.000741 0 0.00074125 -0.3 0.00074175 0.3 0.000742 0 0.00074225 -0.3 0.00074275 0.3 0.000743 0 0.00074325 -0.3 0.00074375 0.3 0.000744 0 0.00074425 -0.3 0.00074475 0.3 0.000745 0 0.00074525 -0.3 0.00074575 0.3 0.000746 0 0.00074625 -0.3 0.00074675 0.3 0.000747 0 0.00074725 -0.3 0.00074775 0.3 0.000748 0 0.00074825 -0.3 0.00074875 0.3 0.000749 0 0.00074925 -0.3 0.00074975 0.3 0.00075 0 0.00075025 -0.3 0.00075075 0.3 0.000751 0 0.00075125 -0.3 0.00075175 0.3 0.000752 0 0.00075225 -0.3 0.00075275 0.3 0.000753 0 0.00075325 -0.3 0.00075375 0.3 0.000754 0 0.00075425 -0.3 0.00075475 0.3 0.000755 0 0.00075525 -0.3 0.00075575 0.3 0.000756 0 0.00075625 -0.3 0.00075675 0.3 0.000757 0 0.00075725 -0.3 0.00075775 0.3 0.000758 0 0.00075825 -0.3 0.00075875 0.3 0.000759 0 0.00075925 -0.3 0.00075975 0.3 0.00076 0 0.00076025 -0.3 0.00076075 0.3 0.000761 0 0.00076125 -0.3 0.00076175 0.3 0.000762 0 0.00076225 -0.3 0.00076275 0.3 0.000763 0 0.00076325 -0.3 0.00076375 0.3 0.000764 0 0.00076425 -0.3 0.00076475 0.3 0.000765 0 0.00076525 -0.3 0.00076575 0.3 0.000766 0 0.00076625 -0.3 0.00076675 0.3 0.000767 0 0.00076725 -0.3 0.00076775 0.3 0.000768 0 0.00076825 -0.3 0.00076875 0.3 0.000769 0 0.00076925 -0.3 0.00076975 0.3 0.00077 0 0.00077025 -0.3 0.00077075 0.3 0.000771 0 0.00077125 -0.3 0.00077175 0.3 0.000772 0 0.00077225 -0.3 0.00077275 0.3 0.000773 0 0.00077325 -0.3 0.00077375 0.3 0.000774 0 0.00077425 -0.3 0.00077475 0.3 0.000775 0 0.00077525 -0.3 0.00077575 0.3 0.000776 0 0.00077625 -0.3 0.00077675 0.3 0.000777 0 0.00077725 -0.3 0.00077775 0.3 0.000778 0 0.00077825 -0.3 0.00077875 0.3 0.000779 0 0.00077925 -0.3 0.00077975 0.3 0.00078 0 0.00078025 -0.3 0.00078075 0.3 0.000781 0 0.00078125 -0.3 0.00078175 0.3 0.000782 0 0.00078225 -0.3 0.00078275 0.3 0.000783 0 0.00078325 -0.3 0.00078375 0.3 0.000784 0 0.00078425 -0.3 0.00078475 0.3 0.000785 0 0.00078525 -0.3 0.00078575 0.3 0.000786 0 0.00078625 -0.3 0.00078675 0.3 0.000787 0 0.00078725 -0.3 0.00078775 0.3 0.000788 0 0.00078825 -0.3 0.00078875 0.3 0.000789 0 0.00078925 -0.3 0.00078975 0.3 0.00079 0 0.00079025 -0.3 0.00079075 0.3 0.000791 0 0.00079125 -0.3 0.00079175 0.3 0.000792 0 0.00079225 -0.3 0.00079275 0.3 0.000793 0 0.00079325 -0.3 0.00079375 0.3 0.000794 0 0.00079425 -0.3 0.00079475 0.3 0.000795 0 0.00079525 -0.3 0.00079575 0.3 0.000796 0 0.00079625 -0.3 0.00079675 0.3 0.000797 0 0.00079725 -0.3 0.00079775 0.3 0.000798 0 0.00079825 -0.3 0.00079875 0.3 0.000799 0 0.00079925 -0.3 0.00079975 0.3 0.0008 0 0.00080025 -0.3 0.00080075 0.3 0.000801 0 0.00080125 -0.3 0.00080175 0.3 0.000802 0 0.00080225 -0.3 0.00080275 0.3 0.000803 0 0.00080325 -0.3 0.00080375 0.3 0.000804 0 0.00080425 -0.3 0.00080475 0.3 0.000805 0 0.00080525 -0.3 0.00080575 0.3 0.000806 0 0.00080625 -0.3 0.00080675 0.3 0.000807 0 0.00080725 -0.3 0.00080775 0.3 0.000808 0 0.00080825 -0.3 0.00080875 0.3 0.000809 0 0.00080925 -0.3 0.00080975 0.3 0.00081 0 0.00081025 -0.3 0.00081075 0.3 0.000811 0 0.00081125 -0.3 0.00081175 0.3 0.000812 0 0.00081225 -0.3 0.00081275 0.3 0.000813 0 0.00081325 -0.3 0.00081375 0.3 0.000814 0 0.00081425 -0.3 0.00081475 0.3 0.000815 0 0.00081525 -0.3 0.00081575 0.3 0.000816 0 0.00081625 -0.3 0.00081675 0.3 0.000817 0 0.00081725 -0.3 0.00081775 0.3 0.000818 0 0.00081825 -0.3 0.00081875 0.3 0.000819 0 0.00081925 -0.3 0.00081975 0.3 0.00082 0 0.00082025 -0.3 0.00082075 0.3 0.000821 0 0.00082125 -0.3 0.00082175 0.3 0.000822 0 0.00082225 -0.3 0.00082275 0.3 0.000823 0 0.00082325 -0.3 0.00082375 0.3 0.000824 0 0.00082425 -0.3 0.00082475 0.3 0.000825 0 0.00082525 -0.3 0.00082575 0.3 0.000826 0 0.00082625 -0.3 0.00082675 0.3 0.000827 0 0.00082725 -0.3 0.00082775 0.3 0.000828 0 0.00082825 -0.3 0.00082875 0.3 0.000829 0 0.00082925 -0.3 0.00082975 0.3 0.00083 0 0.00083025 -0.3 0.00083075 0.3 0.000831 0 0.00083125 -0.3 0.00083175 0.3 0.000832 0 0.00083225 -0.3 0.00083275 0.3 0.000833 0 0.00083325 -0.3 0.00083375 0.3 0.000834 0 0.00083425 -0.3 0.00083475 0.3 0.000835 0 0.00083525 -0.3 0.00083575 0.3 0.000836 0 0.00083625 -0.3 0.00083675 0.3 0.000837 0 0.00083725 -0.3 0.00083775 0.3 0.000838 0 0.00083825 -0.3 0.00083875 0.3 0.000839 0 0.00083925 -0.3 0.00083975 0.3 0.00084 0 0.00084025 -0.3 0.00084075 0.3 0.000841 0 0.00084125 -0.3 0.00084175 0.3 0.000842 0 0.00084225 -0.3 0.00084275 0.3 0.000843 0 0.00084325 -0.3 0.00084375 0.3 0.000844 0 0.00084425 -0.3 0.00084475 0.3 0.000845 0 0.00084525 -0.3 0.00084575 0.3 0.000846 0 0.00084625 -0.3 0.00084675 0.3 0.000847 0 0.00084725 -0.3 0.00084775 0.3 0.000848 0 0.00084825 -0.3 0.00084875 0.3 0.000849 0 0.00084925 -0.3 0.00084975 0.3 0.00085 0 0.00085025 -0.3 0.00085075 0.3 0.000851 0 0.00085125 -0.3 0.00085175 0.3 0.000852 0 0.00085225 -0.3 0.00085275 0.3 0.000853 0 0.00085325 -0.3 0.00085375 0.3 0.000854 0 0.00085425 -0.3 0.00085475 0.3 0.000855 0 0.00085525 -0.3 0.00085575 0.3 0.000856 0 0.00085625 -0.3 0.00085675 0.3 0.000857 0 0.00085725 -0.3 0.00085775 0.3 0.000858 0 0.00085825 -0.3 0.00085875 0.3 0.000859 0 0.00085925 -0.3 0.00085975 0.3 0.00086 0 0.00086025 -0.3 0.00086075 0.3 0.000861 0 0.00086125 -0.3 0.00086175 0.3 0.000862 0 0.00086225 -0.3 0.00086275 0.3 0.000863 0 0.00086325 -0.3 0.00086375 0.3 0.000864 0 0.00086425 -0.3 0.00086475 0.3 0.000865 0 0.00086525 -0.3 0.00086575 0.3 0.000866 0 0.00086625 -0.3 0.00086675 0.3 0.000867 0 0.00086725 -0.3 0.00086775 0.3 0.000868 0 0.00086825 -0.3 0.00086875 0.3 0.000869 0 0.00086925 -0.3 0.00086975 0.3 0.00087 0 0.00087025 -0.3 0.00087075 0.3 0.000871 0 0.00087125 -0.3 0.00087175 0.3 0.000872 0 0.00087225 -0.3 0.00087275 0.3 0.000873 0 0.00087325 -0.3 0.00087375 0.3 0.000874 0 0.00087425 -0.3 0.00087475 0.3 0.000875 0 0.00087525 -0.3 0.00087575 0.3 0.000876 0 0.00087625 -0.3 0.00087675 0.3 0.000877 0 0.00087725 -0.3 0.00087775 0.3 0.000878 0 0.00087825 -0.3 0.00087875 0.3 0.000879 0 0.00087925 -0.3 0.00087975 0.3 0.00088 0 0.00088025 -0.3 0.00088075 0.3 0.000881 0 0.00088125 -0.3 0.00088175 0.3 0.000882 0 0.00088225 -0.3 0.00088275 0.3 0.000883 0 0.00088325 -0.3 0.00088375 0.3 0.000884 0 0.00088425 -0.3 0.00088475 0.3 0.000885 0 0.00088525 -0.3 0.00088575 0.3 0.000886 0 0.00088625 -0.3 0.00088675 0.3 0.000887 0 0.00088725 -0.3 0.00088775 0.3 0.000888 0 0.00088825 -0.3 0.00088875 0.3 0.000889 0 0.00088925 -0.3 0.00088975 0.3 0.00089 0 0.00089025 -0.3 0.00089075 0.3 0.000891 0 0.00089125 -0.3 0.00089175 0.3 0.000892 0 0.00089225 -0.3 0.00089275 0.3 0.000893 0 0.00089325 -0.3 0.00089375 0.3 0.000894 0 0.00089425 -0.3 0.00089475 0.3 0.000895 0 0.00089525 -0.3 0.00089575 0.3 0.000896 0 0.00089625 -0.3 0.00089675 0.3 0.000897 0 0.00089725 -0.3 0.00089775 0.3 0.000898 0 0.00089825 -0.3 0.00089875 0.3 0.000899 0 0.00089925 -0.3 0.00089975 0.3 0.0009 0 0.00090025 -0.3 0.00090075 0.3 0.000901 0 0.00090125 -0.3 0.00090175 0.3 0.000902 0 0.00090225 -0.3 0.00090275 0.3 0.000903 0 0.00090325 -0.3 0.00090375 0.3 0.000904 0 0.00090425 -0.3 0.00090475 0.3 0.000905 0 0.00090525 -0.3 0.00090575 0.3 0.000906 0 0.00090625 -0.3 0.00090675 0.3 0.000907 0 0.00090725 -0.3 0.00090775 0.3 0.000908 0 0.00090825 -0.3 0.00090875 0.3 0.000909 0 0.00090925 -0.3 0.00090975 0.3 0.00091 0 0.00091025 -0.3 0.00091075 0.3 0.000911 0 0.00091125 -0.3 0.00091175 0.3 0.000912 0 0.00091225 -0.3 0.00091275 0.3 0.000913 0 0.00091325 -0.3 0.00091375 0.3 0.000914 0 0.00091425 -0.3 0.00091475 0.3 0.000915 0 0.00091525 -0.3 0.00091575 0.3 0.000916 0 0.00091625 -0.3 0.00091675 0.3 0.000917 0 0.00091725 -0.3 0.00091775 0.3 0.000918 0 0.00091825 -0.3 0.00091875 0.3 0.000919 0 0.00091925 -0.3 0.00091975 0.3 0.00092 0 0.00092025 -0.3 0.00092075 0.3 0.000921 0 0.00092125 -0.3 0.00092175 0.3 0.000922 0 0.00092225 -0.3 0.00092275 0.3 0.000923 0 0.00092325 -0.3 0.00092375 0.3 0.000924 0 0.00092425 -0.3 0.00092475 0.3 0.000925 0 0.00092525 -0.3 0.00092575 0.3 0.000926 0 0.00092625 -0.3 0.00092675 0.3 0.000927 0 0.00092725 -0.3 0.00092775 0.3 0.000928 0 0.00092825 -0.3 0.00092875 0.3 0.000929 0 0.00092925 -0.3 0.00092975 0.3 0.00093 0 0.00093025 -0.3 0.00093075 0.3 0.000931 0 0.00093125 -0.3 0.00093175 0.3 0.000932 0 0.00093225 -0.3 0.00093275 0.3 0.000933 0 0.00093325 -0.3 0.00093375 0.3 0.000934 0 0.00093425 -0.3 0.00093475 0.3 0.000935 0 0.00093525 -0.3 0.00093575 0.3 0.000936 0 0.00093625 -0.3 0.00093675 0.3 0.000937 0 0.00093725 -0.3 0.00093775 0.3 0.000938 0 0.00093825 -0.3 0.00093875 0.3 0.000939 0 0.00093925 -0.3 0.00093975 0.3 0.00094 0 0.00094025 -0.3 0.00094075 0.3 0.000941 0 0.00094125 -0.3 0.00094175 0.3 0.000942 0 0.00094225 -0.3 0.00094275 0.3 0.000943 0 0.00094325 -0.3 0.00094375 0.3 0.000944 0 0.00094425 -0.3 0.00094475 0.3 0.000945 0 0.00094525 -0.3 0.00094575 0.3 0.000946 0 0.00094625 -0.3 0.00094675 0.3 0.000947 0 0.00094725 -0.3 0.00094775 0.3 0.000948 0 0.00094825 -0.3 0.00094875 0.3 0.000949 0 0.00094925 -0.3 0.00094975 0.3 0.00095 0 0.00095025 -0.3 0.00095075 0.3 0.000951 0 0.00095125 -0.3 0.00095175 0.3 0.000952 0 0.00095225 -0.3 0.00095275 0.3 0.000953 0 0.00095325 -0.3 0.00095375 0.3 0.000954 0 0.00095425 -0.3 0.00095475 0.3 0.000955 0 0.00095525 -0.3 0.00095575 0.3 0.000956 0 0.00095625 -0.3 0.00095675 0.3 0.000957 0 0.00095725 -0.3 0.00095775 0.3 0.000958 0 0.00095825 -0.3 0.00095875 0.3 0.000959 0 0.00095925 -0.3 0.00095975 0.3 0.00096 0 0.00096025 -0.3 0.00096075 0.3 0.000961 0 0.00096125 -0.3 0.00096175 0.3 0.000962 0 0.00096225 -0.3 0.00096275 0.3 0.000963 0 0.00096325 -0.3 0.00096375 0.3 0.000964 0 0.00096425 -0.3 0.00096475 0.3 0.000965 0 0.00096525 -0.3 0.00096575 0.3 0.000966 0 0.00096625 -0.3 0.00096675 0.3 0.000967 0 0.00096725 -0.3 0.00096775 0.3 0.000968 0 0.00096825 -0.3 0.00096875 0.3 0.000969 0 0.00096925 -0.3 0.00096975 0.3 0.00097 0 0.00097025 -0.3 0.00097075 0.3 0.000971 0 0.00097125 -0.3 0.00097175 0.3 0.000972 0 0.00097225 -0.3 0.00097275 0.3 0.000973 0 0.00097325 -0.3 0.00097375 0.3 0.000974 0 0.00097425 -0.3 0.00097475 0.3 0.000975 0 0.00097525 -0.3 0.00097575 0.3 0.000976 0 0.00097625 -0.3 0.00097675 0.3 0.000977 0 0.00097725 -0.3 0.00097775 0.3 0.000978 0 0.00097825 -0.3 0.00097875 0.3 0.000979 0 0.00097925 -0.3 0.00097975 0.3 0.00098 0 0.00098025 -0.3 0.00098075 0.3 0.000981 0 0.00098125 -0.3 0.00098175 0.3 0.000982 0 0.00098225 -0.3 0.00098275 0.3 0.000983 0 0.00098325 -0.3 0.00098375 0.3 0.000984 0 0.00098425 -0.3 0.00098475 0.3 0.000985 0 0.00098525 -0.3 0.00098575 0.3 0.000986 0 0.00098625 -0.3 0.00098675 0.3 0.000987 0 0.00098725 -0.3 0.00098775 0.3 0.000988 0 0.00098825 -0.3 0.00098875 0.3 0.000989 0 0.00098925 -0.3 0.00098975 0.3 0.00099 0 0.00099025 -0.3 0.00099075 0.3 0.000991 0 0.00099125 -0.3 0.00099175 0.3 0.000992 0 0.00099225 -0.3 0.00099275 0.3 0.000993 0 0.00099325 -0.3 0.00099375 0.3 0.000994 0 0.00099425 -0.3 0.00099475 0.3 0.000995 0 0.00099525 -0.3 0.00099575 0.3 0.000996 0 0.00099625 -0.3 0.00099675 0.3 0.000997 0 0.00099725 -0.3 0.00099775 0.3 0.000998 0 0.00099825 -0.3 0.00099875 0.3 0.000999 0 0.00099925 -0.3 0.00099975 0.3 0.001 0 0.00100025 -0.3 0.00100075 0.3 0.001001 0 0.00100125 -0.3 0.00100175 0.3 0.001002 0 0.00100225 -0.3 0.00100275 0.3 0.001003 0 0.00100325 -0.3 0.00100375 0.3 0.001004 0 0.00100425 -0.3 0.00100475 0.3 0.001005 0 0.001007 0)
* +-0.3 V from s0 = -1, 1000 cycles at 1 MHz
N2 p2 0 q2 fecap_generic s0=-1 area=1e-10
V2 p2 0 pwl(0 0 5e-06 0 5.25e-06 -0.3 5.75e-06 0.3 6e-06 0 6.25e-06 -0.3 6.75e-06 0.3 7e-06 0 7.25e-06 -0.3 7.75e-06 0.3 8e-06 0 8.25e-06 -0.3 8.75e-06 0.3 9e-06 0 9.25e-06 -0.3 9.75e-06 0.3 1e-05 0 1.025e-05 -0.3 1.075e-05 0.3 1.1e-05 0 1.125e-05 -0.3 1.175e-05 0.3 1.2e-05 0 1.225e-05 -0.3 1.275e-05 0.3 1.3e-05 0 1.325e-05 -0.3 1.375e-05 0.3 1.4e-05 0 1.425e-05 -0.3 1.475e-05 0.3 1.5e-05 0 1.525e-05 -0.3 1.575e-05 0.3 1.6e-05 0 1.625e-05 -0.3 1.675e-05 0.3 1.7e-05 0 1.725e-05 -0.3 1.775e-05 0.3 1.8e-05 0 1.825e-05 -0.3 1.875e-05 0.3 1.9e-05 0 1.925e-05 -0.3 1.975e-05 0.3 2e-05 0 2.025e-05 -0.3 2.075e-05 0.3 2.1e-05 0 2.125e-05 -0.3 2.175e-05 0.3 2.2e-05 0 2.225e-05 -0.3 2.275e-05 0.3 2.3e-05 0 2.325e-05 -0.3 2.375e-05 0.3 2.4e-05 0 2.425e-05 -0.3 2.475e-05 0.3 2.5e-05 0 2.525e-05 -0.3 2.575e-05 0.3 2.6e-05 0 2.625e-05 -0.3 2.675e-05 0.3 2.7e-05 0 2.725e-05 -0.3 2.775e-05 0.3 2.8e-05 0 2.825e-05 -0.3 2.875e-05 0.3 2.9e-05 0 2.925e-05 -0.3 2.975e-05 0.3 3e-05 0 3.025e-05 -0.3 3.075e-05 0.3 3.1e-05 0 3.125e-05 -0.3 3.175e-05 0.3 3.2e-05 0 3.225e-05 -0.3 3.275e-05 0.3 3.3e-05 0 3.325e-05 -0.3 3.375e-05 0.3 3.4e-05 0 3.425e-05 -0.3 3.475e-05 0.3 3.5e-05 0 3.525e-05 -0.3 3.575e-05 0.3 3.6e-05 0 3.625e-05 -0.3 3.675e-05 0.3 3.7e-05 0 3.725e-05 -0.3 3.775e-05 0.3 3.8e-05 0 3.825e-05 -0.3 3.875e-05 0.3 3.9e-05 0 3.925e-05 -0.3 3.975e-05 0.3 4e-05 0 4.025e-05 -0.3 4.075e-05 0.3 4.1e-05 0 4.125e-05 -0.3 4.175e-05 0.3 4.2e-05 0 4.225e-05 -0.3 4.275e-05 0.3 4.3e-05 0 4.325e-05 -0.3 4.375e-05 0.3 4.4e-05 0 4.425e-05 -0.3 4.475e-05 0.3 4.5e-05 0 4.525e-05 -0.3 4.575e-05 0.3 4.6e-05 0 4.625e-05 -0.3 4.675e-05 0.3 4.7e-05 0 4.725e-05 -0.3 4.775e-05 0.3 4.8e-05 0 4.825e-05 -0.3 4.875e-05 0.3 4.9e-05 0 4.925e-05 -0.3 4.975e-05 0.3 5e-05 0 5.025e-05 -0.3 5.075e-05 0.3 5.1e-05 0 5.125e-05 -0.3 5.175e-05 0.3 5.2e-05 0 5.225e-05 -0.3 5.275e-05 0.3 5.3e-05 0 5.325e-05 -0.3 5.375e-05 0.3 5.4e-05 0 5.425e-05 -0.3 5.475e-05 0.3 5.5e-05 0 5.525e-05 -0.3 5.575e-05 0.3 5.6e-05 0 5.625e-05 -0.3 5.675e-05 0.3 5.7e-05 0 5.725e-05 -0.3 5.775e-05 0.3 5.8e-05 0 5.825e-05 -0.3 5.875e-05 0.3 5.9e-05 0 5.925e-05 -0.3 5.975e-05 0.3 6e-05 0 6.025e-05 -0.3 6.075e-05 0.3 6.1e-05 0 6.125e-05 -0.3 6.175e-05 0.3 6.2e-05 0 6.225e-05 -0.3 6.275e-05 0.3 6.3e-05 0 6.325e-05 -0.3 6.375e-05 0.3 6.4e-05 0 6.425e-05 -0.3 6.475e-05 0.3 6.5e-05 0 6.525e-05 -0.3 6.575e-05 0.3 6.6e-05 0 6.625e-05 -0.3 6.675e-05 0.3 6.7e-05 0 6.725e-05 -0.3 6.775e-05 0.3 6.8e-05 0 6.825e-05 -0.3 6.875e-05 0.3 6.9e-05 0 6.925e-05 -0.3 6.975e-05 0.3 7e-05 0 7.025e-05 -0.3 7.075e-05 0.3 7.1e-05 0 7.125e-05 -0.3 7.175e-05 0.3 7.2e-05 0 7.225e-05 -0.3 7.275e-05 0.3 7.3e-05 0 7.325e-05 -0.3 7.375e-05 0.3 7.4e-05 0 7.425e-05 -0.3 7.475e-05 0.3 7.5e-05 0 7.525e-05 -0.3 7.575e-05 0.3 7.6e-05 0 7.625e-05 -0.3 7.675e-05 0.3 7.7e-05 0 7.725e-05 -0.3 7.775e-05 0.3 7.8e-05 0 7.825e-05 -0.3 7.875e-05 0.3 7.9e-05 0 7.925e-05 -0.3 7.975e-05 0.3 8e-05 0 8.025e-05 -0.3 8.075e-05 0.3 8.1e-05 0 8.125e-05 -0.3 8.175e-05 0.3 8.2e-05 0 8.225e-05 -0.3 8.275e-05 0.3 8.3e-05 0 8.325e-05 -0.3 8.375e-05 0.3 8.4e-05 0 8.425e-05 -0.3 8.475e-05 0.3 8.5e-05 0 8.525e-05 -0.3 8.575e-05 0.3 8.6e-05 0 8.625e-05 -0.3 8.675e-05 0.3 8.7e-05 0 8.725e-05 -0.3 8.775e-05 0.3 8.8e-05 0 8.825e-05 -0.3 8.875e-05 0.3 8.9e-05 0 8.925e-05 -0.3 8.975e-05 0.3 9e-05 0 9.025e-05 -0.3 9.075e-05 0.3 9.1e-05 0 9.125e-05 -0.3 9.175e-05 0.3 9.2e-05 0 9.225e-05 -0.3 9.275e-05 0.3 9.3e-05 0 9.325e-05 -0.3 9.375e-05 0.3 9.4e-05 0 9.425e-05 -0.3 9.475e-05 0.3 9.5e-05 0 9.525e-05 -0.3 9.575e-05 0.3 9.6e-05 0 9.625e-05 -0.3 9.675e-05 0.3 9.7e-05 0 9.725e-05 -0.3 9.775e-05 0.3 9.8e-05 0 9.825e-05 -0.3 9.875e-05 0.3 9.9e-05 0 9.925e-05 -0.3 9.975e-05 0.3 0.0001 0 0.00010025 -0.3 0.00010075 0.3 0.000101 0 0.00010125 -0.3 0.00010175 0.3 0.000102 0 0.00010225 -0.3 0.00010275 0.3 0.000103 0 0.00010325 -0.3 0.00010375 0.3 0.000104 0 0.00010425 -0.3 0.00010475 0.3 0.000105 0 0.00010525 -0.3 0.00010575 0.3 0.000106 0 0.00010625 -0.3 0.00010675 0.3 0.000107 0 0.00010725 -0.3 0.00010775 0.3 0.000108 0 0.00010825 -0.3 0.00010875 0.3 0.000109 0 0.00010925 -0.3 0.00010975 0.3 0.00011 0 0.00011025 -0.3 0.00011075 0.3 0.000111 0 0.00011125 -0.3 0.00011175 0.3 0.000112 0 0.00011225 -0.3 0.00011275 0.3 0.000113 0 0.00011325 -0.3 0.00011375 0.3 0.000114 0 0.00011425 -0.3 0.00011475 0.3 0.000115 0 0.00011525 -0.3 0.00011575 0.3 0.000116 0 0.00011625 -0.3 0.00011675 0.3 0.000117 0 0.00011725 -0.3 0.00011775 0.3 0.000118 0 0.00011825 -0.3 0.00011875 0.3 0.000119 0 0.00011925 -0.3 0.00011975 0.3 0.00012 0 0.00012025 -0.3 0.00012075 0.3 0.000121 0 0.00012125 -0.3 0.00012175 0.3 0.000122 0 0.00012225 -0.3 0.00012275 0.3 0.000123 0 0.00012325 -0.3 0.00012375 0.3 0.000124 0 0.00012425 -0.3 0.00012475 0.3 0.000125 0 0.00012525 -0.3 0.00012575 0.3 0.000126 0 0.00012625 -0.3 0.00012675 0.3 0.000127 0 0.00012725 -0.3 0.00012775 0.3 0.000128 0 0.00012825 -0.3 0.00012875 0.3 0.000129 0 0.00012925 -0.3 0.00012975 0.3 0.00013 0 0.00013025 -0.3 0.00013075 0.3 0.000131 0 0.00013125 -0.3 0.00013175 0.3 0.000132 0 0.00013225 -0.3 0.00013275 0.3 0.000133 0 0.00013325 -0.3 0.00013375 0.3 0.000134 0 0.00013425 -0.3 0.00013475 0.3 0.000135 0 0.00013525 -0.3 0.00013575 0.3 0.000136 0 0.00013625 -0.3 0.00013675 0.3 0.000137 0 0.00013725 -0.3 0.00013775 0.3 0.000138 0 0.00013825 -0.3 0.00013875 0.3 0.000139 0 0.00013925 -0.3 0.00013975 0.3 0.00014 0 0.00014025 -0.3 0.00014075 0.3 0.000141 0 0.00014125 -0.3 0.00014175 0.3 0.000142 0 0.00014225 -0.3 0.00014275 0.3 0.000143 0 0.00014325 -0.3 0.00014375 0.3 0.000144 0 0.00014425 -0.3 0.00014475 0.3 0.000145 0 0.00014525 -0.3 0.00014575 0.3 0.000146 0 0.00014625 -0.3 0.00014675 0.3 0.000147 0 0.00014725 -0.3 0.00014775 0.3 0.000148 0 0.00014825 -0.3 0.00014875 0.3 0.000149 0 0.00014925 -0.3 0.00014975 0.3 0.00015 0 0.00015025 -0.3 0.00015075 0.3 0.000151 0 0.00015125 -0.3 0.00015175 0.3 0.000152 0 0.00015225 -0.3 0.00015275 0.3 0.000153 0 0.00015325 -0.3 0.00015375 0.3 0.000154 0 0.00015425 -0.3 0.00015475 0.3 0.000155 0 0.00015525 -0.3 0.00015575 0.3 0.000156 0 0.00015625 -0.3 0.00015675 0.3 0.000157 0 0.00015725 -0.3 0.00015775 0.3 0.000158 0 0.00015825 -0.3 0.00015875 0.3 0.000159 0 0.00015925 -0.3 0.00015975 0.3 0.00016 0 0.00016025 -0.3 0.00016075 0.3 0.000161 0 0.00016125 -0.3 0.00016175 0.3 0.000162 0 0.00016225 -0.3 0.00016275 0.3 0.000163 0 0.00016325 -0.3 0.00016375 0.3 0.000164 0 0.00016425 -0.3 0.00016475 0.3 0.000165 0 0.00016525 -0.3 0.00016575 0.3 0.000166 0 0.00016625 -0.3 0.00016675 0.3 0.000167 0 0.00016725 -0.3 0.00016775 0.3 0.000168 0 0.00016825 -0.3 0.00016875 0.3 0.000169 0 0.00016925 -0.3 0.00016975 0.3 0.00017 0 0.00017025 -0.3 0.00017075 0.3 0.000171 0 0.00017125 -0.3 0.00017175 0.3 0.000172 0 0.00017225 -0.3 0.00017275 0.3 0.000173 0 0.00017325 -0.3 0.00017375 0.3 0.000174 0 0.00017425 -0.3 0.00017475 0.3 0.000175 0 0.00017525 -0.3 0.00017575 0.3 0.000176 0 0.00017625 -0.3 0.00017675 0.3 0.000177 0 0.00017725 -0.3 0.00017775 0.3 0.000178 0 0.00017825 -0.3 0.00017875 0.3 0.000179 0 0.00017925 -0.3 0.00017975 0.3 0.00018 0 0.00018025 -0.3 0.00018075 0.3 0.000181 0 0.00018125 -0.3 0.00018175 0.3 0.000182 0 0.00018225 -0.3 0.00018275 0.3 0.000183 0 0.00018325 -0.3 0.00018375 0.3 0.000184 0 0.00018425 -0.3 0.00018475 0.3 0.000185 0 0.00018525 -0.3 0.00018575 0.3 0.000186 0 0.00018625 -0.3 0.00018675 0.3 0.000187 0 0.00018725 -0.3 0.00018775 0.3 0.000188 0 0.00018825 -0.3 0.00018875 0.3 0.000189 0 0.00018925 -0.3 0.00018975 0.3 0.00019 0 0.00019025 -0.3 0.00019075 0.3 0.000191 0 0.00019125 -0.3 0.00019175 0.3 0.000192 0 0.00019225 -0.3 0.00019275 0.3 0.000193 0 0.00019325 -0.3 0.00019375 0.3 0.000194 0 0.00019425 -0.3 0.00019475 0.3 0.000195 0 0.00019525 -0.3 0.00019575 0.3 0.000196 0 0.00019625 -0.3 0.00019675 0.3 0.000197 0 0.00019725 -0.3 0.00019775 0.3 0.000198 0 0.00019825 -0.3 0.00019875 0.3 0.000199 0 0.00019925 -0.3 0.00019975 0.3 0.0002 0 0.00020025 -0.3 0.00020075 0.3 0.000201 0 0.00020125 -0.3 0.00020175 0.3 0.000202 0 0.00020225 -0.3 0.00020275 0.3 0.000203 0 0.00020325 -0.3 0.00020375 0.3 0.000204 0 0.00020425 -0.3 0.00020475 0.3 0.000205 0 0.00020525 -0.3 0.00020575 0.3 0.000206 0 0.00020625 -0.3 0.00020675 0.3 0.000207 0 0.00020725 -0.3 0.00020775 0.3 0.000208 0 0.00020825 -0.3 0.00020875 0.3 0.000209 0 0.00020925 -0.3 0.00020975 0.3 0.00021 0 0.00021025 -0.3 0.00021075 0.3 0.000211 0 0.00021125 -0.3 0.00021175 0.3 0.000212 0 0.00021225 -0.3 0.00021275 0.3 0.000213 0 0.00021325 -0.3 0.00021375 0.3 0.000214 0 0.00021425 -0.3 0.00021475 0.3 0.000215 0 0.00021525 -0.3 0.00021575 0.3 0.000216 0 0.00021625 -0.3 0.00021675 0.3 0.000217 0 0.00021725 -0.3 0.00021775 0.3 0.000218 0 0.00021825 -0.3 0.00021875 0.3 0.000219 0 0.00021925 -0.3 0.00021975 0.3 0.00022 0 0.00022025 -0.3 0.00022075 0.3 0.000221 0 0.00022125 -0.3 0.00022175 0.3 0.000222 0 0.00022225 -0.3 0.00022275 0.3 0.000223 0 0.00022325 -0.3 0.00022375 0.3 0.000224 0 0.00022425 -0.3 0.00022475 0.3 0.000225 0 0.00022525 -0.3 0.00022575 0.3 0.000226 0 0.00022625 -0.3 0.00022675 0.3 0.000227 0 0.00022725 -0.3 0.00022775 0.3 0.000228 0 0.00022825 -0.3 0.00022875 0.3 0.000229 0 0.00022925 -0.3 0.00022975 0.3 0.00023 0 0.00023025 -0.3 0.00023075 0.3 0.000231 0 0.00023125 -0.3 0.00023175 0.3 0.000232 0 0.00023225 -0.3 0.00023275 0.3 0.000233 0 0.00023325 -0.3 0.00023375 0.3 0.000234 0 0.00023425 -0.3 0.00023475 0.3 0.000235 0 0.00023525 -0.3 0.00023575 0.3 0.000236 0 0.00023625 -0.3 0.00023675 0.3 0.000237 0 0.00023725 -0.3 0.00023775 0.3 0.000238 0 0.00023825 -0.3 0.00023875 0.3 0.000239 0 0.00023925 -0.3 0.00023975 0.3 0.00024 0 0.00024025 -0.3 0.00024075 0.3 0.000241 0 0.00024125 -0.3 0.00024175 0.3 0.000242 0 0.00024225 -0.3 0.00024275 0.3 0.000243 0 0.00024325 -0.3 0.00024375 0.3 0.000244 0 0.00024425 -0.3 0.00024475 0.3 0.000245 0 0.00024525 -0.3 0.00024575 0.3 0.000246 0 0.00024625 -0.3 0.00024675 0.3 0.000247 0 0.00024725 -0.3 0.00024775 0.3 0.000248 0 0.00024825 -0.3 0.00024875 0.3 0.000249 0 0.00024925 -0.3 0.00024975 0.3 0.00025 0 0.00025025 -0.3 0.00025075 0.3 0.000251 0 0.00025125 -0.3 0.00025175 0.3 0.000252 0 0.00025225 -0.3 0.00025275 0.3 0.000253 0 0.00025325 -0.3 0.00025375 0.3 0.000254 0 0.00025425 -0.3 0.00025475 0.3 0.000255 0 0.00025525 -0.3 0.00025575 0.3 0.000256 0 0.00025625 -0.3 0.00025675 0.3 0.000257 0 0.00025725 -0.3 0.00025775 0.3 0.000258 0 0.00025825 -0.3 0.00025875 0.3 0.000259 0 0.00025925 -0.3 0.00025975 0.3 0.00026 0 0.00026025 -0.3 0.00026075 0.3 0.000261 0 0.00026125 -0.3 0.00026175 0.3 0.000262 0 0.00026225 -0.3 0.00026275 0.3 0.000263 0 0.00026325 -0.3 0.00026375 0.3 0.000264 0 0.00026425 -0.3 0.00026475 0.3 0.000265 0 0.00026525 -0.3 0.00026575 0.3 0.000266 0 0.00026625 -0.3 0.00026675 0.3 0.000267 0 0.00026725 -0.3 0.00026775 0.3 0.000268 0 0.00026825 -0.3 0.00026875 0.3 0.000269 0 0.00026925 -0.3 0.00026975 0.3 0.00027 0 0.00027025 -0.3 0.00027075 0.3 0.000271 0 0.00027125 -0.3 0.00027175 0.3 0.000272 0 0.00027225 -0.3 0.00027275 0.3 0.000273 0 0.00027325 -0.3 0.00027375 0.3 0.000274 0 0.00027425 -0.3 0.00027475 0.3 0.000275 0 0.00027525 -0.3 0.00027575 0.3 0.000276 0 0.00027625 -0.3 0.00027675 0.3 0.000277 0 0.00027725 -0.3 0.00027775 0.3 0.000278 0 0.00027825 -0.3 0.00027875 0.3 0.000279 0 0.00027925 -0.3 0.00027975 0.3 0.00028 0 0.00028025 -0.3 0.00028075 0.3 0.000281 0 0.00028125 -0.3 0.00028175 0.3 0.000282 0 0.00028225 -0.3 0.00028275 0.3 0.000283 0 0.00028325 -0.3 0.00028375 0.3 0.000284 0 0.00028425 -0.3 0.00028475 0.3 0.000285 0 0.00028525 -0.3 0.00028575 0.3 0.000286 0 0.00028625 -0.3 0.00028675 0.3 0.000287 0 0.00028725 -0.3 0.00028775 0.3 0.000288 0 0.00028825 -0.3 0.00028875 0.3 0.000289 0 0.00028925 -0.3 0.00028975 0.3 0.00029 0 0.00029025 -0.3 0.00029075 0.3 0.000291 0 0.00029125 -0.3 0.00029175 0.3 0.000292 0 0.00029225 -0.3 0.00029275 0.3 0.000293 0 0.00029325 -0.3 0.00029375 0.3 0.000294 0 0.00029425 -0.3 0.00029475 0.3 0.000295 0 0.00029525 -0.3 0.00029575 0.3 0.000296 0 0.00029625 -0.3 0.00029675 0.3 0.000297 0 0.00029725 -0.3 0.00029775 0.3 0.000298 0 0.00029825 -0.3 0.00029875 0.3 0.000299 0 0.00029925 -0.3 0.00029975 0.3 0.0003 0 0.00030025 -0.3 0.00030075 0.3 0.000301 0 0.00030125 -0.3 0.00030175 0.3 0.000302 0 0.00030225 -0.3 0.00030275 0.3 0.000303 0 0.00030325 -0.3 0.00030375 0.3 0.000304 0 0.00030425 -0.3 0.00030475 0.3 0.000305 0 0.00030525 -0.3 0.00030575 0.3 0.000306 0 0.00030625 -0.3 0.00030675 0.3 0.000307 0 0.00030725 -0.3 0.00030775 0.3 0.000308 0 0.00030825 -0.3 0.00030875 0.3 0.000309 0 0.00030925 -0.3 0.00030975 0.3 0.00031 0 0.00031025 -0.3 0.00031075 0.3 0.000311 0 0.00031125 -0.3 0.00031175 0.3 0.000312 0 0.00031225 -0.3 0.00031275 0.3 0.000313 0 0.00031325 -0.3 0.00031375 0.3 0.000314 0 0.00031425 -0.3 0.00031475 0.3 0.000315 0 0.00031525 -0.3 0.00031575 0.3 0.000316 0 0.00031625 -0.3 0.00031675 0.3 0.000317 0 0.00031725 -0.3 0.00031775 0.3 0.000318 0 0.00031825 -0.3 0.00031875 0.3 0.000319 0 0.00031925 -0.3 0.00031975 0.3 0.00032 0 0.00032025 -0.3 0.00032075 0.3 0.000321 0 0.00032125 -0.3 0.00032175 0.3 0.000322 0 0.00032225 -0.3 0.00032275 0.3 0.000323 0 0.00032325 -0.3 0.00032375 0.3 0.000324 0 0.00032425 -0.3 0.00032475 0.3 0.000325 0 0.00032525 -0.3 0.00032575 0.3 0.000326 0 0.00032625 -0.3 0.00032675 0.3 0.000327 0 0.00032725 -0.3 0.00032775 0.3 0.000328 0 0.00032825 -0.3 0.00032875 0.3 0.000329 0 0.00032925 -0.3 0.00032975 0.3 0.00033 0 0.00033025 -0.3 0.00033075 0.3 0.000331 0 0.00033125 -0.3 0.00033175 0.3 0.000332 0 0.00033225 -0.3 0.00033275 0.3 0.000333 0 0.00033325 -0.3 0.00033375 0.3 0.000334 0 0.00033425 -0.3 0.00033475 0.3 0.000335 0 0.00033525 -0.3 0.00033575 0.3 0.000336 0 0.00033625 -0.3 0.00033675 0.3 0.000337 0 0.00033725 -0.3 0.00033775 0.3 0.000338 0 0.00033825 -0.3 0.00033875 0.3 0.000339 0 0.00033925 -0.3 0.00033975 0.3 0.00034 0 0.00034025 -0.3 0.00034075 0.3 0.000341 0 0.00034125 -0.3 0.00034175 0.3 0.000342 0 0.00034225 -0.3 0.00034275 0.3 0.000343 0 0.00034325 -0.3 0.00034375 0.3 0.000344 0 0.00034425 -0.3 0.00034475 0.3 0.000345 0 0.00034525 -0.3 0.00034575 0.3 0.000346 0 0.00034625 -0.3 0.00034675 0.3 0.000347 0 0.00034725 -0.3 0.00034775 0.3 0.000348 0 0.00034825 -0.3 0.00034875 0.3 0.000349 0 0.00034925 -0.3 0.00034975 0.3 0.00035 0 0.00035025 -0.3 0.00035075 0.3 0.000351 0 0.00035125 -0.3 0.00035175 0.3 0.000352 0 0.00035225 -0.3 0.00035275 0.3 0.000353 0 0.00035325 -0.3 0.00035375 0.3 0.000354 0 0.00035425 -0.3 0.00035475 0.3 0.000355 0 0.00035525 -0.3 0.00035575 0.3 0.000356 0 0.00035625 -0.3 0.00035675 0.3 0.000357 0 0.00035725 -0.3 0.00035775 0.3 0.000358 0 0.00035825 -0.3 0.00035875 0.3 0.000359 0 0.00035925 -0.3 0.00035975 0.3 0.00036 0 0.00036025 -0.3 0.00036075 0.3 0.000361 0 0.00036125 -0.3 0.00036175 0.3 0.000362 0 0.00036225 -0.3 0.00036275 0.3 0.000363 0 0.00036325 -0.3 0.00036375 0.3 0.000364 0 0.00036425 -0.3 0.00036475 0.3 0.000365 0 0.00036525 -0.3 0.00036575 0.3 0.000366 0 0.00036625 -0.3 0.00036675 0.3 0.000367 0 0.00036725 -0.3 0.00036775 0.3 0.000368 0 0.00036825 -0.3 0.00036875 0.3 0.000369 0 0.00036925 -0.3 0.00036975 0.3 0.00037 0 0.00037025 -0.3 0.00037075 0.3 0.000371 0 0.00037125 -0.3 0.00037175 0.3 0.000372 0 0.00037225 -0.3 0.00037275 0.3 0.000373 0 0.00037325 -0.3 0.00037375 0.3 0.000374 0 0.00037425 -0.3 0.00037475 0.3 0.000375 0 0.00037525 -0.3 0.00037575 0.3 0.000376 0 0.00037625 -0.3 0.00037675 0.3 0.000377 0 0.00037725 -0.3 0.00037775 0.3 0.000378 0 0.00037825 -0.3 0.00037875 0.3 0.000379 0 0.00037925 -0.3 0.00037975 0.3 0.00038 0 0.00038025 -0.3 0.00038075 0.3 0.000381 0 0.00038125 -0.3 0.00038175 0.3 0.000382 0 0.00038225 -0.3 0.00038275 0.3 0.000383 0 0.00038325 -0.3 0.00038375 0.3 0.000384 0 0.00038425 -0.3 0.00038475 0.3 0.000385 0 0.00038525 -0.3 0.00038575 0.3 0.000386 0 0.00038625 -0.3 0.00038675 0.3 0.000387 0 0.00038725 -0.3 0.00038775 0.3 0.000388 0 0.00038825 -0.3 0.00038875 0.3 0.000389 0 0.00038925 -0.3 0.00038975 0.3 0.00039 0 0.00039025 -0.3 0.00039075 0.3 0.000391 0 0.00039125 -0.3 0.00039175 0.3 0.000392 0 0.00039225 -0.3 0.00039275 0.3 0.000393 0 0.00039325 -0.3 0.00039375 0.3 0.000394 0 0.00039425 -0.3 0.00039475 0.3 0.000395 0 0.00039525 -0.3 0.00039575 0.3 0.000396 0 0.00039625 -0.3 0.00039675 0.3 0.000397 0 0.00039725 -0.3 0.00039775 0.3 0.000398 0 0.00039825 -0.3 0.00039875 0.3 0.000399 0 0.00039925 -0.3 0.00039975 0.3 0.0004 0 0.00040025 -0.3 0.00040075 0.3 0.000401 0 0.00040125 -0.3 0.00040175 0.3 0.000402 0 0.00040225 -0.3 0.00040275 0.3 0.000403 0 0.00040325 -0.3 0.00040375 0.3 0.000404 0 0.00040425 -0.3 0.00040475 0.3 0.000405 0 0.00040525 -0.3 0.00040575 0.3 0.000406 0 0.00040625 -0.3 0.00040675 0.3 0.000407 0 0.00040725 -0.3 0.00040775 0.3 0.000408 0 0.00040825 -0.3 0.00040875 0.3 0.000409 0 0.00040925 -0.3 0.00040975 0.3 0.00041 0 0.00041025 -0.3 0.00041075 0.3 0.000411 0 0.00041125 -0.3 0.00041175 0.3 0.000412 0 0.00041225 -0.3 0.00041275 0.3 0.000413 0 0.00041325 -0.3 0.00041375 0.3 0.000414 0 0.00041425 -0.3 0.00041475 0.3 0.000415 0 0.00041525 -0.3 0.00041575 0.3 0.000416 0 0.00041625 -0.3 0.00041675 0.3 0.000417 0 0.00041725 -0.3 0.00041775 0.3 0.000418 0 0.00041825 -0.3 0.00041875 0.3 0.000419 0 0.00041925 -0.3 0.00041975 0.3 0.00042 0 0.00042025 -0.3 0.00042075 0.3 0.000421 0 0.00042125 -0.3 0.00042175 0.3 0.000422 0 0.00042225 -0.3 0.00042275 0.3 0.000423 0 0.00042325 -0.3 0.00042375 0.3 0.000424 0 0.00042425 -0.3 0.00042475 0.3 0.000425 0 0.00042525 -0.3 0.00042575 0.3 0.000426 0 0.00042625 -0.3 0.00042675 0.3 0.000427 0 0.00042725 -0.3 0.00042775 0.3 0.000428 0 0.00042825 -0.3 0.00042875 0.3 0.000429 0 0.00042925 -0.3 0.00042975 0.3 0.00043 0 0.00043025 -0.3 0.00043075 0.3 0.000431 0 0.00043125 -0.3 0.00043175 0.3 0.000432 0 0.00043225 -0.3 0.00043275 0.3 0.000433 0 0.00043325 -0.3 0.00043375 0.3 0.000434 0 0.00043425 -0.3 0.00043475 0.3 0.000435 0 0.00043525 -0.3 0.00043575 0.3 0.000436 0 0.00043625 -0.3 0.00043675 0.3 0.000437 0 0.00043725 -0.3 0.00043775 0.3 0.000438 0 0.00043825 -0.3 0.00043875 0.3 0.000439 0 0.00043925 -0.3 0.00043975 0.3 0.00044 0 0.00044025 -0.3 0.00044075 0.3 0.000441 0 0.00044125 -0.3 0.00044175 0.3 0.000442 0 0.00044225 -0.3 0.00044275 0.3 0.000443 0 0.00044325 -0.3 0.00044375 0.3 0.000444 0 0.00044425 -0.3 0.00044475 0.3 0.000445 0 0.00044525 -0.3 0.00044575 0.3 0.000446 0 0.00044625 -0.3 0.00044675 0.3 0.000447 0 0.00044725 -0.3 0.00044775 0.3 0.000448 0 0.00044825 -0.3 0.00044875 0.3 0.000449 0 0.00044925 -0.3 0.00044975 0.3 0.00045 0 0.00045025 -0.3 0.00045075 0.3 0.000451 0 0.00045125 -0.3 0.00045175 0.3 0.000452 0 0.00045225 -0.3 0.00045275 0.3 0.000453 0 0.00045325 -0.3 0.00045375 0.3 0.000454 0 0.00045425 -0.3 0.00045475 0.3 0.000455 0 0.00045525 -0.3 0.00045575 0.3 0.000456 0 0.00045625 -0.3 0.00045675 0.3 0.000457 0 0.00045725 -0.3 0.00045775 0.3 0.000458 0 0.00045825 -0.3 0.00045875 0.3 0.000459 0 0.00045925 -0.3 0.00045975 0.3 0.00046 0 0.00046025 -0.3 0.00046075 0.3 0.000461 0 0.00046125 -0.3 0.00046175 0.3 0.000462 0 0.00046225 -0.3 0.00046275 0.3 0.000463 0 0.00046325 -0.3 0.00046375 0.3 0.000464 0 0.00046425 -0.3 0.00046475 0.3 0.000465 0 0.00046525 -0.3 0.00046575 0.3 0.000466 0 0.00046625 -0.3 0.00046675 0.3 0.000467 0 0.00046725 -0.3 0.00046775 0.3 0.000468 0 0.00046825 -0.3 0.00046875 0.3 0.000469 0 0.00046925 -0.3 0.00046975 0.3 0.00047 0 0.00047025 -0.3 0.00047075 0.3 0.000471 0 0.00047125 -0.3 0.00047175 0.3 0.000472 0 0.00047225 -0.3 0.00047275 0.3 0.000473 0 0.00047325 -0.3 0.00047375 0.3 0.000474 0 0.00047425 -0.3 0.00047475 0.3 0.000475 0 0.00047525 -0.3 0.00047575 0.3 0.000476 0 0.00047625 -0.3 0.00047675 0.3 0.000477 0 0.00047725 -0.3 0.00047775 0.3 0.000478 0 0.00047825 -0.3 0.00047875 0.3 0.000479 0 0.00047925 -0.3 0.00047975 0.3 0.00048 0 0.00048025 -0.3 0.00048075 0.3 0.000481 0 0.00048125 -0.3 0.00048175 0.3 0.000482 0 0.00048225 -0.3 0.00048275 0.3 0.000483 0 0.00048325 -0.3 0.00048375 0.3 0.000484 0 0.00048425 -0.3 0.00048475 0.3 0.000485 0 0.00048525 -0.3 0.00048575 0.3 0.000486 0 0.00048625 -0.3 0.00048675 0.3 0.000487 0 0.00048725 -0.3 0.00048775 0.3 0.000488 0 0.00048825 -0.3 0.00048875 0.3 0.000489 0 0.00048925 -0.3 0.00048975 0.3 0.00049 0 0.00049025 -0.3 0.00049075 0.3 0.000491 0 0.00049125 -0.3 0.00049175 0.3 0.000492 0 0.00049225 -0.3 0.00049275 0.3 0.000493 0 0.00049325 -0.3 0.00049375 0.3 0.000494 0 0.00049425 -0.3 0.00049475 0.3 0.000495 0 0.00049525 -0.3 0.00049575 0.3 0.000496 0 0.00049625 -0.3 0.00049675 0.3 0.000497 0 0.00049725 -0.3 0.00049775 0.3 0.000498 0 0.00049825 -0.3 0.00049875 0.3 0.000499 0 0.00049925 -0.3 0.00049975 0.3 0.0005 0 0.00050025 -0.3 0.00050075 0.3 0.000501 0 0.00050125 -0.3 0.00050175 0.3 0.000502 0 0.00050225 -0.3 0.00050275 0.3 0.000503 0 0.00050325 -0.3 0.00050375 0.3 0.000504 0 0.00050425 -0.3 0.00050475 0.3 0.000505 0 0.00050525 -0.3 0.00050575 0.3 0.000506 0 0.00050625 -0.3 0.00050675 0.3 0.000507 0 0.00050725 -0.3 0.00050775 0.3 0.000508 0 0.00050825 -0.3 0.00050875 0.3 0.000509 0 0.00050925 -0.3 0.00050975 0.3 0.00051 0 0.00051025 -0.3 0.00051075 0.3 0.000511 0 0.00051125 -0.3 0.00051175 0.3 0.000512 0 0.00051225 -0.3 0.00051275 0.3 0.000513 0 0.00051325 -0.3 0.00051375 0.3 0.000514 0 0.00051425 -0.3 0.00051475 0.3 0.000515 0 0.00051525 -0.3 0.00051575 0.3 0.000516 0 0.00051625 -0.3 0.00051675 0.3 0.000517 0 0.00051725 -0.3 0.00051775 0.3 0.000518 0 0.00051825 -0.3 0.00051875 0.3 0.000519 0 0.00051925 -0.3 0.00051975 0.3 0.00052 0 0.00052025 -0.3 0.00052075 0.3 0.000521 0 0.00052125 -0.3 0.00052175 0.3 0.000522 0 0.00052225 -0.3 0.00052275 0.3 0.000523 0 0.00052325 -0.3 0.00052375 0.3 0.000524 0 0.00052425 -0.3 0.00052475 0.3 0.000525 0 0.00052525 -0.3 0.00052575 0.3 0.000526 0 0.00052625 -0.3 0.00052675 0.3 0.000527 0 0.00052725 -0.3 0.00052775 0.3 0.000528 0 0.00052825 -0.3 0.00052875 0.3 0.000529 0 0.00052925 -0.3 0.00052975 0.3 0.00053 0 0.00053025 -0.3 0.00053075 0.3 0.000531 0 0.00053125 -0.3 0.00053175 0.3 0.000532 0 0.00053225 -0.3 0.00053275 0.3 0.000533 0 0.00053325 -0.3 0.00053375 0.3 0.000534 0 0.00053425 -0.3 0.00053475 0.3 0.000535 0 0.00053525 -0.3 0.00053575 0.3 0.000536 0 0.00053625 -0.3 0.00053675 0.3 0.000537 0 0.00053725 -0.3 0.00053775 0.3 0.000538 0 0.00053825 -0.3 0.00053875 0.3 0.000539 0 0.00053925 -0.3 0.00053975 0.3 0.00054 0 0.00054025 -0.3 0.00054075 0.3 0.000541 0 0.00054125 -0.3 0.00054175 0.3 0.000542 0 0.00054225 -0.3 0.00054275 0.3 0.000543 0 0.00054325 -0.3 0.00054375 0.3 0.000544 0 0.00054425 -0.3 0.00054475 0.3 0.000545 0 0.00054525 -0.3 0.00054575 0.3 0.000546 0 0.00054625 -0.3 0.00054675 0.3 0.000547 0 0.00054725 -0.3 0.00054775 0.3 0.000548 0 0.00054825 -0.3 0.00054875 0.3 0.000549 0 0.00054925 -0.3 0.00054975 0.3 0.00055 0 0.00055025 -0.3 0.00055075 0.3 0.000551 0 0.00055125 -0.3 0.00055175 0.3 0.000552 0 0.00055225 -0.3 0.00055275 0.3 0.000553 0 0.00055325 -0.3 0.00055375 0.3 0.000554 0 0.00055425 -0.3 0.00055475 0.3 0.000555 0 0.00055525 -0.3 0.00055575 0.3 0.000556 0 0.00055625 -0.3 0.00055675 0.3 0.000557 0 0.00055725 -0.3 0.00055775 0.3 0.000558 0 0.00055825 -0.3 0.00055875 0.3 0.000559 0 0.00055925 -0.3 0.00055975 0.3 0.00056 0 0.00056025 -0.3 0.00056075 0.3 0.000561 0 0.00056125 -0.3 0.00056175 0.3 0.000562 0 0.00056225 -0.3 0.00056275 0.3 0.000563 0 0.00056325 -0.3 0.00056375 0.3 0.000564 0 0.00056425 -0.3 0.00056475 0.3 0.000565 0 0.00056525 -0.3 0.00056575 0.3 0.000566 0 0.00056625 -0.3 0.00056675 0.3 0.000567 0 0.00056725 -0.3 0.00056775 0.3 0.000568 0 0.00056825 -0.3 0.00056875 0.3 0.000569 0 0.00056925 -0.3 0.00056975 0.3 0.00057 0 0.00057025 -0.3 0.00057075 0.3 0.000571 0 0.00057125 -0.3 0.00057175 0.3 0.000572 0 0.00057225 -0.3 0.00057275 0.3 0.000573 0 0.00057325 -0.3 0.00057375 0.3 0.000574 0 0.00057425 -0.3 0.00057475 0.3 0.000575 0 0.00057525 -0.3 0.00057575 0.3 0.000576 0 0.00057625 -0.3 0.00057675 0.3 0.000577 0 0.00057725 -0.3 0.00057775 0.3 0.000578 0 0.00057825 -0.3 0.00057875 0.3 0.000579 0 0.00057925 -0.3 0.00057975 0.3 0.00058 0 0.00058025 -0.3 0.00058075 0.3 0.000581 0 0.00058125 -0.3 0.00058175 0.3 0.000582 0 0.00058225 -0.3 0.00058275 0.3 0.000583 0 0.00058325 -0.3 0.00058375 0.3 0.000584 0 0.00058425 -0.3 0.00058475 0.3 0.000585 0 0.00058525 -0.3 0.00058575 0.3 0.000586 0 0.00058625 -0.3 0.00058675 0.3 0.000587 0 0.00058725 -0.3 0.00058775 0.3 0.000588 0 0.00058825 -0.3 0.00058875 0.3 0.000589 0 0.00058925 -0.3 0.00058975 0.3 0.00059 0 0.00059025 -0.3 0.00059075 0.3 0.000591 0 0.00059125 -0.3 0.00059175 0.3 0.000592 0 0.00059225 -0.3 0.00059275 0.3 0.000593 0 0.00059325 -0.3 0.00059375 0.3 0.000594 0 0.00059425 -0.3 0.00059475 0.3 0.000595 0 0.00059525 -0.3 0.00059575 0.3 0.000596 0 0.00059625 -0.3 0.00059675 0.3 0.000597 0 0.00059725 -0.3 0.00059775 0.3 0.000598 0 0.00059825 -0.3 0.00059875 0.3 0.000599 0 0.00059925 -0.3 0.00059975 0.3 0.0006 0 0.00060025 -0.3 0.00060075 0.3 0.000601 0 0.00060125 -0.3 0.00060175 0.3 0.000602 0 0.00060225 -0.3 0.00060275 0.3 0.000603 0 0.00060325 -0.3 0.00060375 0.3 0.000604 0 0.00060425 -0.3 0.00060475 0.3 0.000605 0 0.00060525 -0.3 0.00060575 0.3 0.000606 0 0.00060625 -0.3 0.00060675 0.3 0.000607 0 0.00060725 -0.3 0.00060775 0.3 0.000608 0 0.00060825 -0.3 0.00060875 0.3 0.000609 0 0.00060925 -0.3 0.00060975 0.3 0.00061 0 0.00061025 -0.3 0.00061075 0.3 0.000611 0 0.00061125 -0.3 0.00061175 0.3 0.000612 0 0.00061225 -0.3 0.00061275 0.3 0.000613 0 0.00061325 -0.3 0.00061375 0.3 0.000614 0 0.00061425 -0.3 0.00061475 0.3 0.000615 0 0.00061525 -0.3 0.00061575 0.3 0.000616 0 0.00061625 -0.3 0.00061675 0.3 0.000617 0 0.00061725 -0.3 0.00061775 0.3 0.000618 0 0.00061825 -0.3 0.00061875 0.3 0.000619 0 0.00061925 -0.3 0.00061975 0.3 0.00062 0 0.00062025 -0.3 0.00062075 0.3 0.000621 0 0.00062125 -0.3 0.00062175 0.3 0.000622 0 0.00062225 -0.3 0.00062275 0.3 0.000623 0 0.00062325 -0.3 0.00062375 0.3 0.000624 0 0.00062425 -0.3 0.00062475 0.3 0.000625 0 0.00062525 -0.3 0.00062575 0.3 0.000626 0 0.00062625 -0.3 0.00062675 0.3 0.000627 0 0.00062725 -0.3 0.00062775 0.3 0.000628 0 0.00062825 -0.3 0.00062875 0.3 0.000629 0 0.00062925 -0.3 0.00062975 0.3 0.00063 0 0.00063025 -0.3 0.00063075 0.3 0.000631 0 0.00063125 -0.3 0.00063175 0.3 0.000632 0 0.00063225 -0.3 0.00063275 0.3 0.000633 0 0.00063325 -0.3 0.00063375 0.3 0.000634 0 0.00063425 -0.3 0.00063475 0.3 0.000635 0 0.00063525 -0.3 0.00063575 0.3 0.000636 0 0.00063625 -0.3 0.00063675 0.3 0.000637 0 0.00063725 -0.3 0.00063775 0.3 0.000638 0 0.00063825 -0.3 0.00063875 0.3 0.000639 0 0.00063925 -0.3 0.00063975 0.3 0.00064 0 0.00064025 -0.3 0.00064075 0.3 0.000641 0 0.00064125 -0.3 0.00064175 0.3 0.000642 0 0.00064225 -0.3 0.00064275 0.3 0.000643 0 0.00064325 -0.3 0.00064375 0.3 0.000644 0 0.00064425 -0.3 0.00064475 0.3 0.000645 0 0.00064525 -0.3 0.00064575 0.3 0.000646 0 0.00064625 -0.3 0.00064675 0.3 0.000647 0 0.00064725 -0.3 0.00064775 0.3 0.000648 0 0.00064825 -0.3 0.00064875 0.3 0.000649 0 0.00064925 -0.3 0.00064975 0.3 0.00065 0 0.00065025 -0.3 0.00065075 0.3 0.000651 0 0.00065125 -0.3 0.00065175 0.3 0.000652 0 0.00065225 -0.3 0.00065275 0.3 0.000653 0 0.00065325 -0.3 0.00065375 0.3 0.000654 0 0.00065425 -0.3 0.00065475 0.3 0.000655 0 0.00065525 -0.3 0.00065575 0.3 0.000656 0 0.00065625 -0.3 0.00065675 0.3 0.000657 0 0.00065725 -0.3 0.00065775 0.3 0.000658 0 0.00065825 -0.3 0.00065875 0.3 0.000659 0 0.00065925 -0.3 0.00065975 0.3 0.00066 0 0.00066025 -0.3 0.00066075 0.3 0.000661 0 0.00066125 -0.3 0.00066175 0.3 0.000662 0 0.00066225 -0.3 0.00066275 0.3 0.000663 0 0.00066325 -0.3 0.00066375 0.3 0.000664 0 0.00066425 -0.3 0.00066475 0.3 0.000665 0 0.00066525 -0.3 0.00066575 0.3 0.000666 0 0.00066625 -0.3 0.00066675 0.3 0.000667 0 0.00066725 -0.3 0.00066775 0.3 0.000668 0 0.00066825 -0.3 0.00066875 0.3 0.000669 0 0.00066925 -0.3 0.00066975 0.3 0.00067 0 0.00067025 -0.3 0.00067075 0.3 0.000671 0 0.00067125 -0.3 0.00067175 0.3 0.000672 0 0.00067225 -0.3 0.00067275 0.3 0.000673 0 0.00067325 -0.3 0.00067375 0.3 0.000674 0 0.00067425 -0.3 0.00067475 0.3 0.000675 0 0.00067525 -0.3 0.00067575 0.3 0.000676 0 0.00067625 -0.3 0.00067675 0.3 0.000677 0 0.00067725 -0.3 0.00067775 0.3 0.000678 0 0.00067825 -0.3 0.00067875 0.3 0.000679 0 0.00067925 -0.3 0.00067975 0.3 0.00068 0 0.00068025 -0.3 0.00068075 0.3 0.000681 0 0.00068125 -0.3 0.00068175 0.3 0.000682 0 0.00068225 -0.3 0.00068275 0.3 0.000683 0 0.00068325 -0.3 0.00068375 0.3 0.000684 0 0.00068425 -0.3 0.00068475 0.3 0.000685 0 0.00068525 -0.3 0.00068575 0.3 0.000686 0 0.00068625 -0.3 0.00068675 0.3 0.000687 0 0.00068725 -0.3 0.00068775 0.3 0.000688 0 0.00068825 -0.3 0.00068875 0.3 0.000689 0 0.00068925 -0.3 0.00068975 0.3 0.00069 0 0.00069025 -0.3 0.00069075 0.3 0.000691 0 0.00069125 -0.3 0.00069175 0.3 0.000692 0 0.00069225 -0.3 0.00069275 0.3 0.000693 0 0.00069325 -0.3 0.00069375 0.3 0.000694 0 0.00069425 -0.3 0.00069475 0.3 0.000695 0 0.00069525 -0.3 0.00069575 0.3 0.000696 0 0.00069625 -0.3 0.00069675 0.3 0.000697 0 0.00069725 -0.3 0.00069775 0.3 0.000698 0 0.00069825 -0.3 0.00069875 0.3 0.000699 0 0.00069925 -0.3 0.00069975 0.3 0.0007 0 0.00070025 -0.3 0.00070075 0.3 0.000701 0 0.00070125 -0.3 0.00070175 0.3 0.000702 0 0.00070225 -0.3 0.00070275 0.3 0.000703 0 0.00070325 -0.3 0.00070375 0.3 0.000704 0 0.00070425 -0.3 0.00070475 0.3 0.000705 0 0.00070525 -0.3 0.00070575 0.3 0.000706 0 0.00070625 -0.3 0.00070675 0.3 0.000707 0 0.00070725 -0.3 0.00070775 0.3 0.000708 0 0.00070825 -0.3 0.00070875 0.3 0.000709 0 0.00070925 -0.3 0.00070975 0.3 0.00071 0 0.00071025 -0.3 0.00071075 0.3 0.000711 0 0.00071125 -0.3 0.00071175 0.3 0.000712 0 0.00071225 -0.3 0.00071275 0.3 0.000713 0 0.00071325 -0.3 0.00071375 0.3 0.000714 0 0.00071425 -0.3 0.00071475 0.3 0.000715 0 0.00071525 -0.3 0.00071575 0.3 0.000716 0 0.00071625 -0.3 0.00071675 0.3 0.000717 0 0.00071725 -0.3 0.00071775 0.3 0.000718 0 0.00071825 -0.3 0.00071875 0.3 0.000719 0 0.00071925 -0.3 0.00071975 0.3 0.00072 0 0.00072025 -0.3 0.00072075 0.3 0.000721 0 0.00072125 -0.3 0.00072175 0.3 0.000722 0 0.00072225 -0.3 0.00072275 0.3 0.000723 0 0.00072325 -0.3 0.00072375 0.3 0.000724 0 0.00072425 -0.3 0.00072475 0.3 0.000725 0 0.00072525 -0.3 0.00072575 0.3 0.000726 0 0.00072625 -0.3 0.00072675 0.3 0.000727 0 0.00072725 -0.3 0.00072775 0.3 0.000728 0 0.00072825 -0.3 0.00072875 0.3 0.000729 0 0.00072925 -0.3 0.00072975 0.3 0.00073 0 0.00073025 -0.3 0.00073075 0.3 0.000731 0 0.00073125 -0.3 0.00073175 0.3 0.000732 0 0.00073225 -0.3 0.00073275 0.3 0.000733 0 0.00073325 -0.3 0.00073375 0.3 0.000734 0 0.00073425 -0.3 0.00073475 0.3 0.000735 0 0.00073525 -0.3 0.00073575 0.3 0.000736 0 0.00073625 -0.3 0.00073675 0.3 0.000737 0 0.00073725 -0.3 0.00073775 0.3 0.000738 0 0.00073825 -0.3 0.00073875 0.3 0.000739 0 0.00073925 -0.3 0.00073975 0.3 0.00074 0 0.00074025 -0.3 0.00074075 0.3 0.000741 0 0.00074125 -0.3 0.00074175 0.3 0.000742 0 0.00074225 -0.3 0.00074275 0.3 0.000743 0 0.00074325 -0.3 0.00074375 0.3 0.000744 0 0.00074425 -0.3 0.00074475 0.3 0.000745 0 0.00074525 -0.3 0.00074575 0.3 0.000746 0 0.00074625 -0.3 0.00074675 0.3 0.000747 0 0.00074725 -0.3 0.00074775 0.3 0.000748 0 0.00074825 -0.3 0.00074875 0.3 0.000749 0 0.00074925 -0.3 0.00074975 0.3 0.00075 0 0.00075025 -0.3 0.00075075 0.3 0.000751 0 0.00075125 -0.3 0.00075175 0.3 0.000752 0 0.00075225 -0.3 0.00075275 0.3 0.000753 0 0.00075325 -0.3 0.00075375 0.3 0.000754 0 0.00075425 -0.3 0.00075475 0.3 0.000755 0 0.00075525 -0.3 0.00075575 0.3 0.000756 0 0.00075625 -0.3 0.00075675 0.3 0.000757 0 0.00075725 -0.3 0.00075775 0.3 0.000758 0 0.00075825 -0.3 0.00075875 0.3 0.000759 0 0.00075925 -0.3 0.00075975 0.3 0.00076 0 0.00076025 -0.3 0.00076075 0.3 0.000761 0 0.00076125 -0.3 0.00076175 0.3 0.000762 0 0.00076225 -0.3 0.00076275 0.3 0.000763 0 0.00076325 -0.3 0.00076375 0.3 0.000764 0 0.00076425 -0.3 0.00076475 0.3 0.000765 0 0.00076525 -0.3 0.00076575 0.3 0.000766 0 0.00076625 -0.3 0.00076675 0.3 0.000767 0 0.00076725 -0.3 0.00076775 0.3 0.000768 0 0.00076825 -0.3 0.00076875 0.3 0.000769 0 0.00076925 -0.3 0.00076975 0.3 0.00077 0 0.00077025 -0.3 0.00077075 0.3 0.000771 0 0.00077125 -0.3 0.00077175 0.3 0.000772 0 0.00077225 -0.3 0.00077275 0.3 0.000773 0 0.00077325 -0.3 0.00077375 0.3 0.000774 0 0.00077425 -0.3 0.00077475 0.3 0.000775 0 0.00077525 -0.3 0.00077575 0.3 0.000776 0 0.00077625 -0.3 0.00077675 0.3 0.000777 0 0.00077725 -0.3 0.00077775 0.3 0.000778 0 0.00077825 -0.3 0.00077875 0.3 0.000779 0 0.00077925 -0.3 0.00077975 0.3 0.00078 0 0.00078025 -0.3 0.00078075 0.3 0.000781 0 0.00078125 -0.3 0.00078175 0.3 0.000782 0 0.00078225 -0.3 0.00078275 0.3 0.000783 0 0.00078325 -0.3 0.00078375 0.3 0.000784 0 0.00078425 -0.3 0.00078475 0.3 0.000785 0 0.00078525 -0.3 0.00078575 0.3 0.000786 0 0.00078625 -0.3 0.00078675 0.3 0.000787 0 0.00078725 -0.3 0.00078775 0.3 0.000788 0 0.00078825 -0.3 0.00078875 0.3 0.000789 0 0.00078925 -0.3 0.00078975 0.3 0.00079 0 0.00079025 -0.3 0.00079075 0.3 0.000791 0 0.00079125 -0.3 0.00079175 0.3 0.000792 0 0.00079225 -0.3 0.00079275 0.3 0.000793 0 0.00079325 -0.3 0.00079375 0.3 0.000794 0 0.00079425 -0.3 0.00079475 0.3 0.000795 0 0.00079525 -0.3 0.00079575 0.3 0.000796 0 0.00079625 -0.3 0.00079675 0.3 0.000797 0 0.00079725 -0.3 0.00079775 0.3 0.000798 0 0.00079825 -0.3 0.00079875 0.3 0.000799 0 0.00079925 -0.3 0.00079975 0.3 0.0008 0 0.00080025 -0.3 0.00080075 0.3 0.000801 0 0.00080125 -0.3 0.00080175 0.3 0.000802 0 0.00080225 -0.3 0.00080275 0.3 0.000803 0 0.00080325 -0.3 0.00080375 0.3 0.000804 0 0.00080425 -0.3 0.00080475 0.3 0.000805 0 0.00080525 -0.3 0.00080575 0.3 0.000806 0 0.00080625 -0.3 0.00080675 0.3 0.000807 0 0.00080725 -0.3 0.00080775 0.3 0.000808 0 0.00080825 -0.3 0.00080875 0.3 0.000809 0 0.00080925 -0.3 0.00080975 0.3 0.00081 0 0.00081025 -0.3 0.00081075 0.3 0.000811 0 0.00081125 -0.3 0.00081175 0.3 0.000812 0 0.00081225 -0.3 0.00081275 0.3 0.000813 0 0.00081325 -0.3 0.00081375 0.3 0.000814 0 0.00081425 -0.3 0.00081475 0.3 0.000815 0 0.00081525 -0.3 0.00081575 0.3 0.000816 0 0.00081625 -0.3 0.00081675 0.3 0.000817 0 0.00081725 -0.3 0.00081775 0.3 0.000818 0 0.00081825 -0.3 0.00081875 0.3 0.000819 0 0.00081925 -0.3 0.00081975 0.3 0.00082 0 0.00082025 -0.3 0.00082075 0.3 0.000821 0 0.00082125 -0.3 0.00082175 0.3 0.000822 0 0.00082225 -0.3 0.00082275 0.3 0.000823 0 0.00082325 -0.3 0.00082375 0.3 0.000824 0 0.00082425 -0.3 0.00082475 0.3 0.000825 0 0.00082525 -0.3 0.00082575 0.3 0.000826 0 0.00082625 -0.3 0.00082675 0.3 0.000827 0 0.00082725 -0.3 0.00082775 0.3 0.000828 0 0.00082825 -0.3 0.00082875 0.3 0.000829 0 0.00082925 -0.3 0.00082975 0.3 0.00083 0 0.00083025 -0.3 0.00083075 0.3 0.000831 0 0.00083125 -0.3 0.00083175 0.3 0.000832 0 0.00083225 -0.3 0.00083275 0.3 0.000833 0 0.00083325 -0.3 0.00083375 0.3 0.000834 0 0.00083425 -0.3 0.00083475 0.3 0.000835 0 0.00083525 -0.3 0.00083575 0.3 0.000836 0 0.00083625 -0.3 0.00083675 0.3 0.000837 0 0.00083725 -0.3 0.00083775 0.3 0.000838 0 0.00083825 -0.3 0.00083875 0.3 0.000839 0 0.00083925 -0.3 0.00083975 0.3 0.00084 0 0.00084025 -0.3 0.00084075 0.3 0.000841 0 0.00084125 -0.3 0.00084175 0.3 0.000842 0 0.00084225 -0.3 0.00084275 0.3 0.000843 0 0.00084325 -0.3 0.00084375 0.3 0.000844 0 0.00084425 -0.3 0.00084475 0.3 0.000845 0 0.00084525 -0.3 0.00084575 0.3 0.000846 0 0.00084625 -0.3 0.00084675 0.3 0.000847 0 0.00084725 -0.3 0.00084775 0.3 0.000848 0 0.00084825 -0.3 0.00084875 0.3 0.000849 0 0.00084925 -0.3 0.00084975 0.3 0.00085 0 0.00085025 -0.3 0.00085075 0.3 0.000851 0 0.00085125 -0.3 0.00085175 0.3 0.000852 0 0.00085225 -0.3 0.00085275 0.3 0.000853 0 0.00085325 -0.3 0.00085375 0.3 0.000854 0 0.00085425 -0.3 0.00085475 0.3 0.000855 0 0.00085525 -0.3 0.00085575 0.3 0.000856 0 0.00085625 -0.3 0.00085675 0.3 0.000857 0 0.00085725 -0.3 0.00085775 0.3 0.000858 0 0.00085825 -0.3 0.00085875 0.3 0.000859 0 0.00085925 -0.3 0.00085975 0.3 0.00086 0 0.00086025 -0.3 0.00086075 0.3 0.000861 0 0.00086125 -0.3 0.00086175 0.3 0.000862 0 0.00086225 -0.3 0.00086275 0.3 0.000863 0 0.00086325 -0.3 0.00086375 0.3 0.000864 0 0.00086425 -0.3 0.00086475 0.3 0.000865 0 0.00086525 -0.3 0.00086575 0.3 0.000866 0 0.00086625 -0.3 0.00086675 0.3 0.000867 0 0.00086725 -0.3 0.00086775 0.3 0.000868 0 0.00086825 -0.3 0.00086875 0.3 0.000869 0 0.00086925 -0.3 0.00086975 0.3 0.00087 0 0.00087025 -0.3 0.00087075 0.3 0.000871 0 0.00087125 -0.3 0.00087175 0.3 0.000872 0 0.00087225 -0.3 0.00087275 0.3 0.000873 0 0.00087325 -0.3 0.00087375 0.3 0.000874 0 0.00087425 -0.3 0.00087475 0.3 0.000875 0 0.00087525 -0.3 0.00087575 0.3 0.000876 0 0.00087625 -0.3 0.00087675 0.3 0.000877 0 0.00087725 -0.3 0.00087775 0.3 0.000878 0 0.00087825 -0.3 0.00087875 0.3 0.000879 0 0.00087925 -0.3 0.00087975 0.3 0.00088 0 0.00088025 -0.3 0.00088075 0.3 0.000881 0 0.00088125 -0.3 0.00088175 0.3 0.000882 0 0.00088225 -0.3 0.00088275 0.3 0.000883 0 0.00088325 -0.3 0.00088375 0.3 0.000884 0 0.00088425 -0.3 0.00088475 0.3 0.000885 0 0.00088525 -0.3 0.00088575 0.3 0.000886 0 0.00088625 -0.3 0.00088675 0.3 0.000887 0 0.00088725 -0.3 0.00088775 0.3 0.000888 0 0.00088825 -0.3 0.00088875 0.3 0.000889 0 0.00088925 -0.3 0.00088975 0.3 0.00089 0 0.00089025 -0.3 0.00089075 0.3 0.000891 0 0.00089125 -0.3 0.00089175 0.3 0.000892 0 0.00089225 -0.3 0.00089275 0.3 0.000893 0 0.00089325 -0.3 0.00089375 0.3 0.000894 0 0.00089425 -0.3 0.00089475 0.3 0.000895 0 0.00089525 -0.3 0.00089575 0.3 0.000896 0 0.00089625 -0.3 0.00089675 0.3 0.000897 0 0.00089725 -0.3 0.00089775 0.3 0.000898 0 0.00089825 -0.3 0.00089875 0.3 0.000899 0 0.00089925 -0.3 0.00089975 0.3 0.0009 0 0.00090025 -0.3 0.00090075 0.3 0.000901 0 0.00090125 -0.3 0.00090175 0.3 0.000902 0 0.00090225 -0.3 0.00090275 0.3 0.000903 0 0.00090325 -0.3 0.00090375 0.3 0.000904 0 0.00090425 -0.3 0.00090475 0.3 0.000905 0 0.00090525 -0.3 0.00090575 0.3 0.000906 0 0.00090625 -0.3 0.00090675 0.3 0.000907 0 0.00090725 -0.3 0.00090775 0.3 0.000908 0 0.00090825 -0.3 0.00090875 0.3 0.000909 0 0.00090925 -0.3 0.00090975 0.3 0.00091 0 0.00091025 -0.3 0.00091075 0.3 0.000911 0 0.00091125 -0.3 0.00091175 0.3 0.000912 0 0.00091225 -0.3 0.00091275 0.3 0.000913 0 0.00091325 -0.3 0.00091375 0.3 0.000914 0 0.00091425 -0.3 0.00091475 0.3 0.000915 0 0.00091525 -0.3 0.00091575 0.3 0.000916 0 0.00091625 -0.3 0.00091675 0.3 0.000917 0 0.00091725 -0.3 0.00091775 0.3 0.000918 0 0.00091825 -0.3 0.00091875 0.3 0.000919 0 0.00091925 -0.3 0.00091975 0.3 0.00092 0 0.00092025 -0.3 0.00092075 0.3 0.000921 0 0.00092125 -0.3 0.00092175 0.3 0.000922 0 0.00092225 -0.3 0.00092275 0.3 0.000923 0 0.00092325 -0.3 0.00092375 0.3 0.000924 0 0.00092425 -0.3 0.00092475 0.3 0.000925 0 0.00092525 -0.3 0.00092575 0.3 0.000926 0 0.00092625 -0.3 0.00092675 0.3 0.000927 0 0.00092725 -0.3 0.00092775 0.3 0.000928 0 0.00092825 -0.3 0.00092875 0.3 0.000929 0 0.00092925 -0.3 0.00092975 0.3 0.00093 0 0.00093025 -0.3 0.00093075 0.3 0.000931 0 0.00093125 -0.3 0.00093175 0.3 0.000932 0 0.00093225 -0.3 0.00093275 0.3 0.000933 0 0.00093325 -0.3 0.00093375 0.3 0.000934 0 0.00093425 -0.3 0.00093475 0.3 0.000935 0 0.00093525 -0.3 0.00093575 0.3 0.000936 0 0.00093625 -0.3 0.00093675 0.3 0.000937 0 0.00093725 -0.3 0.00093775 0.3 0.000938 0 0.00093825 -0.3 0.00093875 0.3 0.000939 0 0.00093925 -0.3 0.00093975 0.3 0.00094 0 0.00094025 -0.3 0.00094075 0.3 0.000941 0 0.00094125 -0.3 0.00094175 0.3 0.000942 0 0.00094225 -0.3 0.00094275 0.3 0.000943 0 0.00094325 -0.3 0.00094375 0.3 0.000944 0 0.00094425 -0.3 0.00094475 0.3 0.000945 0 0.00094525 -0.3 0.00094575 0.3 0.000946 0 0.00094625 -0.3 0.00094675 0.3 0.000947 0 0.00094725 -0.3 0.00094775 0.3 0.000948 0 0.00094825 -0.3 0.00094875 0.3 0.000949 0 0.00094925 -0.3 0.00094975 0.3 0.00095 0 0.00095025 -0.3 0.00095075 0.3 0.000951 0 0.00095125 -0.3 0.00095175 0.3 0.000952 0 0.00095225 -0.3 0.00095275 0.3 0.000953 0 0.00095325 -0.3 0.00095375 0.3 0.000954 0 0.00095425 -0.3 0.00095475 0.3 0.000955 0 0.00095525 -0.3 0.00095575 0.3 0.000956 0 0.00095625 -0.3 0.00095675 0.3 0.000957 0 0.00095725 -0.3 0.00095775 0.3 0.000958 0 0.00095825 -0.3 0.00095875 0.3 0.000959 0 0.00095925 -0.3 0.00095975 0.3 0.00096 0 0.00096025 -0.3 0.00096075 0.3 0.000961 0 0.00096125 -0.3 0.00096175 0.3 0.000962 0 0.00096225 -0.3 0.00096275 0.3 0.000963 0 0.00096325 -0.3 0.00096375 0.3 0.000964 0 0.00096425 -0.3 0.00096475 0.3 0.000965 0 0.00096525 -0.3 0.00096575 0.3 0.000966 0 0.00096625 -0.3 0.00096675 0.3 0.000967 0 0.00096725 -0.3 0.00096775 0.3 0.000968 0 0.00096825 -0.3 0.00096875 0.3 0.000969 0 0.00096925 -0.3 0.00096975 0.3 0.00097 0 0.00097025 -0.3 0.00097075 0.3 0.000971 0 0.00097125 -0.3 0.00097175 0.3 0.000972 0 0.00097225 -0.3 0.00097275 0.3 0.000973 0 0.00097325 -0.3 0.00097375 0.3 0.000974 0 0.00097425 -0.3 0.00097475 0.3 0.000975 0 0.00097525 -0.3 0.00097575 0.3 0.000976 0 0.00097625 -0.3 0.00097675 0.3 0.000977 0 0.00097725 -0.3 0.00097775 0.3 0.000978 0 0.00097825 -0.3 0.00097875 0.3 0.000979 0 0.00097925 -0.3 0.00097975 0.3 0.00098 0 0.00098025 -0.3 0.00098075 0.3 0.000981 0 0.00098125 -0.3 0.00098175 0.3 0.000982 0 0.00098225 -0.3 0.00098275 0.3 0.000983 0 0.00098325 -0.3 0.00098375 0.3 0.000984 0 0.00098425 -0.3 0.00098475 0.3 0.000985 0 0.00098525 -0.3 0.00098575 0.3 0.000986 0 0.00098625 -0.3 0.00098675 0.3 0.000987 0 0.00098725 -0.3 0.00098775 0.3 0.000988 0 0.00098825 -0.3 0.00098875 0.3 0.000989 0 0.00098925 -0.3 0.00098975 0.3 0.00099 0 0.00099025 -0.3 0.00099075 0.3 0.000991 0 0.00099125 -0.3 0.00099175 0.3 0.000992 0 0.00099225 -0.3 0.00099275 0.3 0.000993 0 0.00099325 -0.3 0.00099375 0.3 0.000994 0 0.00099425 -0.3 0.00099475 0.3 0.000995 0 0.00099525 -0.3 0.00099575 0.3 0.000996 0 0.00099625 -0.3 0.00099675 0.3 0.000997 0 0.00099725 -0.3 0.00099775 0.3 0.000998 0 0.00099825 -0.3 0.00099875 0.3 0.000999 0 0.00099925 -0.3 0.00099975 0.3 0.001 0 0.00100025 -0.3 0.00100075 0.3 0.001001 0 0.00100125 -0.3 0.00100175 0.3 0.001002 0 0.00100225 -0.3 0.00100275 0.3 0.001003 0 0.00100325 -0.3 0.00100375 0.3 0.001004 0 0.00100425 -0.3 0.00100475 0.3 0.001005 0 0.001007 0)
* +-0.3 V from a partially switched state, 1000 cycles at 1 MHz
N3 p3 0 q3 fecap_generic s0=-1 area=1e-10
V3 p3 0 pwl(0 0 5e-07 0 5.1e-07 2 1.51e-06 2 1.52e-06 0 5e-06 0 5.25e-06 -0.3 5.75e-06 0.3 6e-06 0 6.25e-06 -0.3 6.75e-06 0.3 7e-06 0 7.25e-06 -0.3 7.75e-06 0.3 8e-06 0 8.25e-06 -0.3 8.75e-06 0.3 9e-06 0 9.25e-06 -0.3 9.75e-06 0.3 1e-05 0 1.025e-05 -0.3 1.075e-05 0.3 1.1e-05 0 1.125e-05 -0.3 1.175e-05 0.3 1.2e-05 0 1.225e-05 -0.3 1.275e-05 0.3 1.3e-05 0 1.325e-05 -0.3 1.375e-05 0.3 1.4e-05 0 1.425e-05 -0.3 1.475e-05 0.3 1.5e-05 0 1.525e-05 -0.3 1.575e-05 0.3 1.6e-05 0 1.625e-05 -0.3 1.675e-05 0.3 1.7e-05 0 1.725e-05 -0.3 1.775e-05 0.3 1.8e-05 0 1.825e-05 -0.3 1.875e-05 0.3 1.9e-05 0 1.925e-05 -0.3 1.975e-05 0.3 2e-05 0 2.025e-05 -0.3 2.075e-05 0.3 2.1e-05 0 2.125e-05 -0.3 2.175e-05 0.3 2.2e-05 0 2.225e-05 -0.3 2.275e-05 0.3 2.3e-05 0 2.325e-05 -0.3 2.375e-05 0.3 2.4e-05 0 2.425e-05 -0.3 2.475e-05 0.3 2.5e-05 0 2.525e-05 -0.3 2.575e-05 0.3 2.6e-05 0 2.625e-05 -0.3 2.675e-05 0.3 2.7e-05 0 2.725e-05 -0.3 2.775e-05 0.3 2.8e-05 0 2.825e-05 -0.3 2.875e-05 0.3 2.9e-05 0 2.925e-05 -0.3 2.975e-05 0.3 3e-05 0 3.025e-05 -0.3 3.075e-05 0.3 3.1e-05 0 3.125e-05 -0.3 3.175e-05 0.3 3.2e-05 0 3.225e-05 -0.3 3.275e-05 0.3 3.3e-05 0 3.325e-05 -0.3 3.375e-05 0.3 3.4e-05 0 3.425e-05 -0.3 3.475e-05 0.3 3.5e-05 0 3.525e-05 -0.3 3.575e-05 0.3 3.6e-05 0 3.625e-05 -0.3 3.675e-05 0.3 3.7e-05 0 3.725e-05 -0.3 3.775e-05 0.3 3.8e-05 0 3.825e-05 -0.3 3.875e-05 0.3 3.9e-05 0 3.925e-05 -0.3 3.975e-05 0.3 4e-05 0 4.025e-05 -0.3 4.075e-05 0.3 4.1e-05 0 4.125e-05 -0.3 4.175e-05 0.3 4.2e-05 0 4.225e-05 -0.3 4.275e-05 0.3 4.3e-05 0 4.325e-05 -0.3 4.375e-05 0.3 4.4e-05 0 4.425e-05 -0.3 4.475e-05 0.3 4.5e-05 0 4.525e-05 -0.3 4.575e-05 0.3 4.6e-05 0 4.625e-05 -0.3 4.675e-05 0.3 4.7e-05 0 4.725e-05 -0.3 4.775e-05 0.3 4.8e-05 0 4.825e-05 -0.3 4.875e-05 0.3 4.9e-05 0 4.925e-05 -0.3 4.975e-05 0.3 5e-05 0 5.025e-05 -0.3 5.075e-05 0.3 5.1e-05 0 5.125e-05 -0.3 5.175e-05 0.3 5.2e-05 0 5.225e-05 -0.3 5.275e-05 0.3 5.3e-05 0 5.325e-05 -0.3 5.375e-05 0.3 5.4e-05 0 5.425e-05 -0.3 5.475e-05 0.3 5.5e-05 0 5.525e-05 -0.3 5.575e-05 0.3 5.6e-05 0 5.625e-05 -0.3 5.675e-05 0.3 5.7e-05 0 5.725e-05 -0.3 5.775e-05 0.3 5.8e-05 0 5.825e-05 -0.3 5.875e-05 0.3 5.9e-05 0 5.925e-05 -0.3 5.975e-05 0.3 6e-05 0 6.025e-05 -0.3 6.075e-05 0.3 6.1e-05 0 6.125e-05 -0.3 6.175e-05 0.3 6.2e-05 0 6.225e-05 -0.3 6.275e-05 0.3 6.3e-05 0 6.325e-05 -0.3 6.375e-05 0.3 6.4e-05 0 6.425e-05 -0.3 6.475e-05 0.3 6.5e-05 0 6.525e-05 -0.3 6.575e-05 0.3 6.6e-05 0 6.625e-05 -0.3 6.675e-05 0.3 6.7e-05 0 6.725e-05 -0.3 6.775e-05 0.3 6.8e-05 0 6.825e-05 -0.3 6.875e-05 0.3 6.9e-05 0 6.925e-05 -0.3 6.975e-05 0.3 7e-05 0 7.025e-05 -0.3 7.075e-05 0.3 7.1e-05 0 7.125e-05 -0.3 7.175e-05 0.3 7.2e-05 0 7.225e-05 -0.3 7.275e-05 0.3 7.3e-05 0 7.325e-05 -0.3 7.375e-05 0.3 7.4e-05 0 7.425e-05 -0.3 7.475e-05 0.3 7.5e-05 0 7.525e-05 -0.3 7.575e-05 0.3 7.6e-05 0 7.625e-05 -0.3 7.675e-05 0.3 7.7e-05 0 7.725e-05 -0.3 7.775e-05 0.3 7.8e-05 0 7.825e-05 -0.3 7.875e-05 0.3 7.9e-05 0 7.925e-05 -0.3 7.975e-05 0.3 8e-05 0 8.025e-05 -0.3 8.075e-05 0.3 8.1e-05 0 8.125e-05 -0.3 8.175e-05 0.3 8.2e-05 0 8.225e-05 -0.3 8.275e-05 0.3 8.3e-05 0 8.325e-05 -0.3 8.375e-05 0.3 8.4e-05 0 8.425e-05 -0.3 8.475e-05 0.3 8.5e-05 0 8.525e-05 -0.3 8.575e-05 0.3 8.6e-05 0 8.625e-05 -0.3 8.675e-05 0.3 8.7e-05 0 8.725e-05 -0.3 8.775e-05 0.3 8.8e-05 0 8.825e-05 -0.3 8.875e-05 0.3 8.9e-05 0 8.925e-05 -0.3 8.975e-05 0.3 9e-05 0 9.025e-05 -0.3 9.075e-05 0.3 9.1e-05 0 9.125e-05 -0.3 9.175e-05 0.3 9.2e-05 0 9.225e-05 -0.3 9.275e-05 0.3 9.3e-05 0 9.325e-05 -0.3 9.375e-05 0.3 9.4e-05 0 9.425e-05 -0.3 9.475e-05 0.3 9.5e-05 0 9.525e-05 -0.3 9.575e-05 0.3 9.6e-05 0 9.625e-05 -0.3 9.675e-05 0.3 9.7e-05 0 9.725e-05 -0.3 9.775e-05 0.3 9.8e-05 0 9.825e-05 -0.3 9.875e-05 0.3 9.9e-05 0 9.925e-05 -0.3 9.975e-05 0.3 0.0001 0 0.00010025 -0.3 0.00010075 0.3 0.000101 0 0.00010125 -0.3 0.00010175 0.3 0.000102 0 0.00010225 -0.3 0.00010275 0.3 0.000103 0 0.00010325 -0.3 0.00010375 0.3 0.000104 0 0.00010425 -0.3 0.00010475 0.3 0.000105 0 0.00010525 -0.3 0.00010575 0.3 0.000106 0 0.00010625 -0.3 0.00010675 0.3 0.000107 0 0.00010725 -0.3 0.00010775 0.3 0.000108 0 0.00010825 -0.3 0.00010875 0.3 0.000109 0 0.00010925 -0.3 0.00010975 0.3 0.00011 0 0.00011025 -0.3 0.00011075 0.3 0.000111 0 0.00011125 -0.3 0.00011175 0.3 0.000112 0 0.00011225 -0.3 0.00011275 0.3 0.000113 0 0.00011325 -0.3 0.00011375 0.3 0.000114 0 0.00011425 -0.3 0.00011475 0.3 0.000115 0 0.00011525 -0.3 0.00011575 0.3 0.000116 0 0.00011625 -0.3 0.00011675 0.3 0.000117 0 0.00011725 -0.3 0.00011775 0.3 0.000118 0 0.00011825 -0.3 0.00011875 0.3 0.000119 0 0.00011925 -0.3 0.00011975 0.3 0.00012 0 0.00012025 -0.3 0.00012075 0.3 0.000121 0 0.00012125 -0.3 0.00012175 0.3 0.000122 0 0.00012225 -0.3 0.00012275 0.3 0.000123 0 0.00012325 -0.3 0.00012375 0.3 0.000124 0 0.00012425 -0.3 0.00012475 0.3 0.000125 0 0.00012525 -0.3 0.00012575 0.3 0.000126 0 0.00012625 -0.3 0.00012675 0.3 0.000127 0 0.00012725 -0.3 0.00012775 0.3 0.000128 0 0.00012825 -0.3 0.00012875 0.3 0.000129 0 0.00012925 -0.3 0.00012975 0.3 0.00013 0 0.00013025 -0.3 0.00013075 0.3 0.000131 0 0.00013125 -0.3 0.00013175 0.3 0.000132 0 0.00013225 -0.3 0.00013275 0.3 0.000133 0 0.00013325 -0.3 0.00013375 0.3 0.000134 0 0.00013425 -0.3 0.00013475 0.3 0.000135 0 0.00013525 -0.3 0.00013575 0.3 0.000136 0 0.00013625 -0.3 0.00013675 0.3 0.000137 0 0.00013725 -0.3 0.00013775 0.3 0.000138 0 0.00013825 -0.3 0.00013875 0.3 0.000139 0 0.00013925 -0.3 0.00013975 0.3 0.00014 0 0.00014025 -0.3 0.00014075 0.3 0.000141 0 0.00014125 -0.3 0.00014175 0.3 0.000142 0 0.00014225 -0.3 0.00014275 0.3 0.000143 0 0.00014325 -0.3 0.00014375 0.3 0.000144 0 0.00014425 -0.3 0.00014475 0.3 0.000145 0 0.00014525 -0.3 0.00014575 0.3 0.000146 0 0.00014625 -0.3 0.00014675 0.3 0.000147 0 0.00014725 -0.3 0.00014775 0.3 0.000148 0 0.00014825 -0.3 0.00014875 0.3 0.000149 0 0.00014925 -0.3 0.00014975 0.3 0.00015 0 0.00015025 -0.3 0.00015075 0.3 0.000151 0 0.00015125 -0.3 0.00015175 0.3 0.000152 0 0.00015225 -0.3 0.00015275 0.3 0.000153 0 0.00015325 -0.3 0.00015375 0.3 0.000154 0 0.00015425 -0.3 0.00015475 0.3 0.000155 0 0.00015525 -0.3 0.00015575 0.3 0.000156 0 0.00015625 -0.3 0.00015675 0.3 0.000157 0 0.00015725 -0.3 0.00015775 0.3 0.000158 0 0.00015825 -0.3 0.00015875 0.3 0.000159 0 0.00015925 -0.3 0.00015975 0.3 0.00016 0 0.00016025 -0.3 0.00016075 0.3 0.000161 0 0.00016125 -0.3 0.00016175 0.3 0.000162 0 0.00016225 -0.3 0.00016275 0.3 0.000163 0 0.00016325 -0.3 0.00016375 0.3 0.000164 0 0.00016425 -0.3 0.00016475 0.3 0.000165 0 0.00016525 -0.3 0.00016575 0.3 0.000166 0 0.00016625 -0.3 0.00016675 0.3 0.000167 0 0.00016725 -0.3 0.00016775 0.3 0.000168 0 0.00016825 -0.3 0.00016875 0.3 0.000169 0 0.00016925 -0.3 0.00016975 0.3 0.00017 0 0.00017025 -0.3 0.00017075 0.3 0.000171 0 0.00017125 -0.3 0.00017175 0.3 0.000172 0 0.00017225 -0.3 0.00017275 0.3 0.000173 0 0.00017325 -0.3 0.00017375 0.3 0.000174 0 0.00017425 -0.3 0.00017475 0.3 0.000175 0 0.00017525 -0.3 0.00017575 0.3 0.000176 0 0.00017625 -0.3 0.00017675 0.3 0.000177 0 0.00017725 -0.3 0.00017775 0.3 0.000178 0 0.00017825 -0.3 0.00017875 0.3 0.000179 0 0.00017925 -0.3 0.00017975 0.3 0.00018 0 0.00018025 -0.3 0.00018075 0.3 0.000181 0 0.00018125 -0.3 0.00018175 0.3 0.000182 0 0.00018225 -0.3 0.00018275 0.3 0.000183 0 0.00018325 -0.3 0.00018375 0.3 0.000184 0 0.00018425 -0.3 0.00018475 0.3 0.000185 0 0.00018525 -0.3 0.00018575 0.3 0.000186 0 0.00018625 -0.3 0.00018675 0.3 0.000187 0 0.00018725 -0.3 0.00018775 0.3 0.000188 0 0.00018825 -0.3 0.00018875 0.3 0.000189 0 0.00018925 -0.3 0.00018975 0.3 0.00019 0 0.00019025 -0.3 0.00019075 0.3 0.000191 0 0.00019125 -0.3 0.00019175 0.3 0.000192 0 0.00019225 -0.3 0.00019275 0.3 0.000193 0 0.00019325 -0.3 0.00019375 0.3 0.000194 0 0.00019425 -0.3 0.00019475 0.3 0.000195 0 0.00019525 -0.3 0.00019575 0.3 0.000196 0 0.00019625 -0.3 0.00019675 0.3 0.000197 0 0.00019725 -0.3 0.00019775 0.3 0.000198 0 0.00019825 -0.3 0.00019875 0.3 0.000199 0 0.00019925 -0.3 0.00019975 0.3 0.0002 0 0.00020025 -0.3 0.00020075 0.3 0.000201 0 0.00020125 -0.3 0.00020175 0.3 0.000202 0 0.00020225 -0.3 0.00020275 0.3 0.000203 0 0.00020325 -0.3 0.00020375 0.3 0.000204 0 0.00020425 -0.3 0.00020475 0.3 0.000205 0 0.00020525 -0.3 0.00020575 0.3 0.000206 0 0.00020625 -0.3 0.00020675 0.3 0.000207 0 0.00020725 -0.3 0.00020775 0.3 0.000208 0 0.00020825 -0.3 0.00020875 0.3 0.000209 0 0.00020925 -0.3 0.00020975 0.3 0.00021 0 0.00021025 -0.3 0.00021075 0.3 0.000211 0 0.00021125 -0.3 0.00021175 0.3 0.000212 0 0.00021225 -0.3 0.00021275 0.3 0.000213 0 0.00021325 -0.3 0.00021375 0.3 0.000214 0 0.00021425 -0.3 0.00021475 0.3 0.000215 0 0.00021525 -0.3 0.00021575 0.3 0.000216 0 0.00021625 -0.3 0.00021675 0.3 0.000217 0 0.00021725 -0.3 0.00021775 0.3 0.000218 0 0.00021825 -0.3 0.00021875 0.3 0.000219 0 0.00021925 -0.3 0.00021975 0.3 0.00022 0 0.00022025 -0.3 0.00022075 0.3 0.000221 0 0.00022125 -0.3 0.00022175 0.3 0.000222 0 0.00022225 -0.3 0.00022275 0.3 0.000223 0 0.00022325 -0.3 0.00022375 0.3 0.000224 0 0.00022425 -0.3 0.00022475 0.3 0.000225 0 0.00022525 -0.3 0.00022575 0.3 0.000226 0 0.00022625 -0.3 0.00022675 0.3 0.000227 0 0.00022725 -0.3 0.00022775 0.3 0.000228 0 0.00022825 -0.3 0.00022875 0.3 0.000229 0 0.00022925 -0.3 0.00022975 0.3 0.00023 0 0.00023025 -0.3 0.00023075 0.3 0.000231 0 0.00023125 -0.3 0.00023175 0.3 0.000232 0 0.00023225 -0.3 0.00023275 0.3 0.000233 0 0.00023325 -0.3 0.00023375 0.3 0.000234 0 0.00023425 -0.3 0.00023475 0.3 0.000235 0 0.00023525 -0.3 0.00023575 0.3 0.000236 0 0.00023625 -0.3 0.00023675 0.3 0.000237 0 0.00023725 -0.3 0.00023775 0.3 0.000238 0 0.00023825 -0.3 0.00023875 0.3 0.000239 0 0.00023925 -0.3 0.00023975 0.3 0.00024 0 0.00024025 -0.3 0.00024075 0.3 0.000241 0 0.00024125 -0.3 0.00024175 0.3 0.000242 0 0.00024225 -0.3 0.00024275 0.3 0.000243 0 0.00024325 -0.3 0.00024375 0.3 0.000244 0 0.00024425 -0.3 0.00024475 0.3 0.000245 0 0.00024525 -0.3 0.00024575 0.3 0.000246 0 0.00024625 -0.3 0.00024675 0.3 0.000247 0 0.00024725 -0.3 0.00024775 0.3 0.000248 0 0.00024825 -0.3 0.00024875 0.3 0.000249 0 0.00024925 -0.3 0.00024975 0.3 0.00025 0 0.00025025 -0.3 0.00025075 0.3 0.000251 0 0.00025125 -0.3 0.00025175 0.3 0.000252 0 0.00025225 -0.3 0.00025275 0.3 0.000253 0 0.00025325 -0.3 0.00025375 0.3 0.000254 0 0.00025425 -0.3 0.00025475 0.3 0.000255 0 0.00025525 -0.3 0.00025575 0.3 0.000256 0 0.00025625 -0.3 0.00025675 0.3 0.000257 0 0.00025725 -0.3 0.00025775 0.3 0.000258 0 0.00025825 -0.3 0.00025875 0.3 0.000259 0 0.00025925 -0.3 0.00025975 0.3 0.00026 0 0.00026025 -0.3 0.00026075 0.3 0.000261 0 0.00026125 -0.3 0.00026175 0.3 0.000262 0 0.00026225 -0.3 0.00026275 0.3 0.000263 0 0.00026325 -0.3 0.00026375 0.3 0.000264 0 0.00026425 -0.3 0.00026475 0.3 0.000265 0 0.00026525 -0.3 0.00026575 0.3 0.000266 0 0.00026625 -0.3 0.00026675 0.3 0.000267 0 0.00026725 -0.3 0.00026775 0.3 0.000268 0 0.00026825 -0.3 0.00026875 0.3 0.000269 0 0.00026925 -0.3 0.00026975 0.3 0.00027 0 0.00027025 -0.3 0.00027075 0.3 0.000271 0 0.00027125 -0.3 0.00027175 0.3 0.000272 0 0.00027225 -0.3 0.00027275 0.3 0.000273 0 0.00027325 -0.3 0.00027375 0.3 0.000274 0 0.00027425 -0.3 0.00027475 0.3 0.000275 0 0.00027525 -0.3 0.00027575 0.3 0.000276 0 0.00027625 -0.3 0.00027675 0.3 0.000277 0 0.00027725 -0.3 0.00027775 0.3 0.000278 0 0.00027825 -0.3 0.00027875 0.3 0.000279 0 0.00027925 -0.3 0.00027975 0.3 0.00028 0 0.00028025 -0.3 0.00028075 0.3 0.000281 0 0.00028125 -0.3 0.00028175 0.3 0.000282 0 0.00028225 -0.3 0.00028275 0.3 0.000283 0 0.00028325 -0.3 0.00028375 0.3 0.000284 0 0.00028425 -0.3 0.00028475 0.3 0.000285 0 0.00028525 -0.3 0.00028575 0.3 0.000286 0 0.00028625 -0.3 0.00028675 0.3 0.000287 0 0.00028725 -0.3 0.00028775 0.3 0.000288 0 0.00028825 -0.3 0.00028875 0.3 0.000289 0 0.00028925 -0.3 0.00028975 0.3 0.00029 0 0.00029025 -0.3 0.00029075 0.3 0.000291 0 0.00029125 -0.3 0.00029175 0.3 0.000292 0 0.00029225 -0.3 0.00029275 0.3 0.000293 0 0.00029325 -0.3 0.00029375 0.3 0.000294 0 0.00029425 -0.3 0.00029475 0.3 0.000295 0 0.00029525 -0.3 0.00029575 0.3 0.000296 0 0.00029625 -0.3 0.00029675 0.3 0.000297 0 0.00029725 -0.3 0.00029775 0.3 0.000298 0 0.00029825 -0.3 0.00029875 0.3 0.000299 0 0.00029925 -0.3 0.00029975 0.3 0.0003 0 0.00030025 -0.3 0.00030075 0.3 0.000301 0 0.00030125 -0.3 0.00030175 0.3 0.000302 0 0.00030225 -0.3 0.00030275 0.3 0.000303 0 0.00030325 -0.3 0.00030375 0.3 0.000304 0 0.00030425 -0.3 0.00030475 0.3 0.000305 0 0.00030525 -0.3 0.00030575 0.3 0.000306 0 0.00030625 -0.3 0.00030675 0.3 0.000307 0 0.00030725 -0.3 0.00030775 0.3 0.000308 0 0.00030825 -0.3 0.00030875 0.3 0.000309 0 0.00030925 -0.3 0.00030975 0.3 0.00031 0 0.00031025 -0.3 0.00031075 0.3 0.000311 0 0.00031125 -0.3 0.00031175 0.3 0.000312 0 0.00031225 -0.3 0.00031275 0.3 0.000313 0 0.00031325 -0.3 0.00031375 0.3 0.000314 0 0.00031425 -0.3 0.00031475 0.3 0.000315 0 0.00031525 -0.3 0.00031575 0.3 0.000316 0 0.00031625 -0.3 0.00031675 0.3 0.000317 0 0.00031725 -0.3 0.00031775 0.3 0.000318 0 0.00031825 -0.3 0.00031875 0.3 0.000319 0 0.00031925 -0.3 0.00031975 0.3 0.00032 0 0.00032025 -0.3 0.00032075 0.3 0.000321 0 0.00032125 -0.3 0.00032175 0.3 0.000322 0 0.00032225 -0.3 0.00032275 0.3 0.000323 0 0.00032325 -0.3 0.00032375 0.3 0.000324 0 0.00032425 -0.3 0.00032475 0.3 0.000325 0 0.00032525 -0.3 0.00032575 0.3 0.000326 0 0.00032625 -0.3 0.00032675 0.3 0.000327 0 0.00032725 -0.3 0.00032775 0.3 0.000328 0 0.00032825 -0.3 0.00032875 0.3 0.000329 0 0.00032925 -0.3 0.00032975 0.3 0.00033 0 0.00033025 -0.3 0.00033075 0.3 0.000331 0 0.00033125 -0.3 0.00033175 0.3 0.000332 0 0.00033225 -0.3 0.00033275 0.3 0.000333 0 0.00033325 -0.3 0.00033375 0.3 0.000334 0 0.00033425 -0.3 0.00033475 0.3 0.000335 0 0.00033525 -0.3 0.00033575 0.3 0.000336 0 0.00033625 -0.3 0.00033675 0.3 0.000337 0 0.00033725 -0.3 0.00033775 0.3 0.000338 0 0.00033825 -0.3 0.00033875 0.3 0.000339 0 0.00033925 -0.3 0.00033975 0.3 0.00034 0 0.00034025 -0.3 0.00034075 0.3 0.000341 0 0.00034125 -0.3 0.00034175 0.3 0.000342 0 0.00034225 -0.3 0.00034275 0.3 0.000343 0 0.00034325 -0.3 0.00034375 0.3 0.000344 0 0.00034425 -0.3 0.00034475 0.3 0.000345 0 0.00034525 -0.3 0.00034575 0.3 0.000346 0 0.00034625 -0.3 0.00034675 0.3 0.000347 0 0.00034725 -0.3 0.00034775 0.3 0.000348 0 0.00034825 -0.3 0.00034875 0.3 0.000349 0 0.00034925 -0.3 0.00034975 0.3 0.00035 0 0.00035025 -0.3 0.00035075 0.3 0.000351 0 0.00035125 -0.3 0.00035175 0.3 0.000352 0 0.00035225 -0.3 0.00035275 0.3 0.000353 0 0.00035325 -0.3 0.00035375 0.3 0.000354 0 0.00035425 -0.3 0.00035475 0.3 0.000355 0 0.00035525 -0.3 0.00035575 0.3 0.000356 0 0.00035625 -0.3 0.00035675 0.3 0.000357 0 0.00035725 -0.3 0.00035775 0.3 0.000358 0 0.00035825 -0.3 0.00035875 0.3 0.000359 0 0.00035925 -0.3 0.00035975 0.3 0.00036 0 0.00036025 -0.3 0.00036075 0.3 0.000361 0 0.00036125 -0.3 0.00036175 0.3 0.000362 0 0.00036225 -0.3 0.00036275 0.3 0.000363 0 0.00036325 -0.3 0.00036375 0.3 0.000364 0 0.00036425 -0.3 0.00036475 0.3 0.000365 0 0.00036525 -0.3 0.00036575 0.3 0.000366 0 0.00036625 -0.3 0.00036675 0.3 0.000367 0 0.00036725 -0.3 0.00036775 0.3 0.000368 0 0.00036825 -0.3 0.00036875 0.3 0.000369 0 0.00036925 -0.3 0.00036975 0.3 0.00037 0 0.00037025 -0.3 0.00037075 0.3 0.000371 0 0.00037125 -0.3 0.00037175 0.3 0.000372 0 0.00037225 -0.3 0.00037275 0.3 0.000373 0 0.00037325 -0.3 0.00037375 0.3 0.000374 0 0.00037425 -0.3 0.00037475 0.3 0.000375 0 0.00037525 -0.3 0.00037575 0.3 0.000376 0 0.00037625 -0.3 0.00037675 0.3 0.000377 0 0.00037725 -0.3 0.00037775 0.3 0.000378 0 0.00037825 -0.3 0.00037875 0.3 0.000379 0 0.00037925 -0.3 0.00037975 0.3 0.00038 0 0.00038025 -0.3 0.00038075 0.3 0.000381 0 0.00038125 -0.3 0.00038175 0.3 0.000382 0 0.00038225 -0.3 0.00038275 0.3 0.000383 0 0.00038325 -0.3 0.00038375 0.3 0.000384 0 0.00038425 -0.3 0.00038475 0.3 0.000385 0 0.00038525 -0.3 0.00038575 0.3 0.000386 0 0.00038625 -0.3 0.00038675 0.3 0.000387 0 0.00038725 -0.3 0.00038775 0.3 0.000388 0 0.00038825 -0.3 0.00038875 0.3 0.000389 0 0.00038925 -0.3 0.00038975 0.3 0.00039 0 0.00039025 -0.3 0.00039075 0.3 0.000391 0 0.00039125 -0.3 0.00039175 0.3 0.000392 0 0.00039225 -0.3 0.00039275 0.3 0.000393 0 0.00039325 -0.3 0.00039375 0.3 0.000394 0 0.00039425 -0.3 0.00039475 0.3 0.000395 0 0.00039525 -0.3 0.00039575 0.3 0.000396 0 0.00039625 -0.3 0.00039675 0.3 0.000397 0 0.00039725 -0.3 0.00039775 0.3 0.000398 0 0.00039825 -0.3 0.00039875 0.3 0.000399 0 0.00039925 -0.3 0.00039975 0.3 0.0004 0 0.00040025 -0.3 0.00040075 0.3 0.000401 0 0.00040125 -0.3 0.00040175 0.3 0.000402 0 0.00040225 -0.3 0.00040275 0.3 0.000403 0 0.00040325 -0.3 0.00040375 0.3 0.000404 0 0.00040425 -0.3 0.00040475 0.3 0.000405 0 0.00040525 -0.3 0.00040575 0.3 0.000406 0 0.00040625 -0.3 0.00040675 0.3 0.000407 0 0.00040725 -0.3 0.00040775 0.3 0.000408 0 0.00040825 -0.3 0.00040875 0.3 0.000409 0 0.00040925 -0.3 0.00040975 0.3 0.00041 0 0.00041025 -0.3 0.00041075 0.3 0.000411 0 0.00041125 -0.3 0.00041175 0.3 0.000412 0 0.00041225 -0.3 0.00041275 0.3 0.000413 0 0.00041325 -0.3 0.00041375 0.3 0.000414 0 0.00041425 -0.3 0.00041475 0.3 0.000415 0 0.00041525 -0.3 0.00041575 0.3 0.000416 0 0.00041625 -0.3 0.00041675 0.3 0.000417 0 0.00041725 -0.3 0.00041775 0.3 0.000418 0 0.00041825 -0.3 0.00041875 0.3 0.000419 0 0.00041925 -0.3 0.00041975 0.3 0.00042 0 0.00042025 -0.3 0.00042075 0.3 0.000421 0 0.00042125 -0.3 0.00042175 0.3 0.000422 0 0.00042225 -0.3 0.00042275 0.3 0.000423 0 0.00042325 -0.3 0.00042375 0.3 0.000424 0 0.00042425 -0.3 0.00042475 0.3 0.000425 0 0.00042525 -0.3 0.00042575 0.3 0.000426 0 0.00042625 -0.3 0.00042675 0.3 0.000427 0 0.00042725 -0.3 0.00042775 0.3 0.000428 0 0.00042825 -0.3 0.00042875 0.3 0.000429 0 0.00042925 -0.3 0.00042975 0.3 0.00043 0 0.00043025 -0.3 0.00043075 0.3 0.000431 0 0.00043125 -0.3 0.00043175 0.3 0.000432 0 0.00043225 -0.3 0.00043275 0.3 0.000433 0 0.00043325 -0.3 0.00043375 0.3 0.000434 0 0.00043425 -0.3 0.00043475 0.3 0.000435 0 0.00043525 -0.3 0.00043575 0.3 0.000436 0 0.00043625 -0.3 0.00043675 0.3 0.000437 0 0.00043725 -0.3 0.00043775 0.3 0.000438 0 0.00043825 -0.3 0.00043875 0.3 0.000439 0 0.00043925 -0.3 0.00043975 0.3 0.00044 0 0.00044025 -0.3 0.00044075 0.3 0.000441 0 0.00044125 -0.3 0.00044175 0.3 0.000442 0 0.00044225 -0.3 0.00044275 0.3 0.000443 0 0.00044325 -0.3 0.00044375 0.3 0.000444 0 0.00044425 -0.3 0.00044475 0.3 0.000445 0 0.00044525 -0.3 0.00044575 0.3 0.000446 0 0.00044625 -0.3 0.00044675 0.3 0.000447 0 0.00044725 -0.3 0.00044775 0.3 0.000448 0 0.00044825 -0.3 0.00044875 0.3 0.000449 0 0.00044925 -0.3 0.00044975 0.3 0.00045 0 0.00045025 -0.3 0.00045075 0.3 0.000451 0 0.00045125 -0.3 0.00045175 0.3 0.000452 0 0.00045225 -0.3 0.00045275 0.3 0.000453 0 0.00045325 -0.3 0.00045375 0.3 0.000454 0 0.00045425 -0.3 0.00045475 0.3 0.000455 0 0.00045525 -0.3 0.00045575 0.3 0.000456 0 0.00045625 -0.3 0.00045675 0.3 0.000457 0 0.00045725 -0.3 0.00045775 0.3 0.000458 0 0.00045825 -0.3 0.00045875 0.3 0.000459 0 0.00045925 -0.3 0.00045975 0.3 0.00046 0 0.00046025 -0.3 0.00046075 0.3 0.000461 0 0.00046125 -0.3 0.00046175 0.3 0.000462 0 0.00046225 -0.3 0.00046275 0.3 0.000463 0 0.00046325 -0.3 0.00046375 0.3 0.000464 0 0.00046425 -0.3 0.00046475 0.3 0.000465 0 0.00046525 -0.3 0.00046575 0.3 0.000466 0 0.00046625 -0.3 0.00046675 0.3 0.000467 0 0.00046725 -0.3 0.00046775 0.3 0.000468 0 0.00046825 -0.3 0.00046875 0.3 0.000469 0 0.00046925 -0.3 0.00046975 0.3 0.00047 0 0.00047025 -0.3 0.00047075 0.3 0.000471 0 0.00047125 -0.3 0.00047175 0.3 0.000472 0 0.00047225 -0.3 0.00047275 0.3 0.000473 0 0.00047325 -0.3 0.00047375 0.3 0.000474 0 0.00047425 -0.3 0.00047475 0.3 0.000475 0 0.00047525 -0.3 0.00047575 0.3 0.000476 0 0.00047625 -0.3 0.00047675 0.3 0.000477 0 0.00047725 -0.3 0.00047775 0.3 0.000478 0 0.00047825 -0.3 0.00047875 0.3 0.000479 0 0.00047925 -0.3 0.00047975 0.3 0.00048 0 0.00048025 -0.3 0.00048075 0.3 0.000481 0 0.00048125 -0.3 0.00048175 0.3 0.000482 0 0.00048225 -0.3 0.00048275 0.3 0.000483 0 0.00048325 -0.3 0.00048375 0.3 0.000484 0 0.00048425 -0.3 0.00048475 0.3 0.000485 0 0.00048525 -0.3 0.00048575 0.3 0.000486 0 0.00048625 -0.3 0.00048675 0.3 0.000487 0 0.00048725 -0.3 0.00048775 0.3 0.000488 0 0.00048825 -0.3 0.00048875 0.3 0.000489 0 0.00048925 -0.3 0.00048975 0.3 0.00049 0 0.00049025 -0.3 0.00049075 0.3 0.000491 0 0.00049125 -0.3 0.00049175 0.3 0.000492 0 0.00049225 -0.3 0.00049275 0.3 0.000493 0 0.00049325 -0.3 0.00049375 0.3 0.000494 0 0.00049425 -0.3 0.00049475 0.3 0.000495 0 0.00049525 -0.3 0.00049575 0.3 0.000496 0 0.00049625 -0.3 0.00049675 0.3 0.000497 0 0.00049725 -0.3 0.00049775 0.3 0.000498 0 0.00049825 -0.3 0.00049875 0.3 0.000499 0 0.00049925 -0.3 0.00049975 0.3 0.0005 0 0.00050025 -0.3 0.00050075 0.3 0.000501 0 0.00050125 -0.3 0.00050175 0.3 0.000502 0 0.00050225 -0.3 0.00050275 0.3 0.000503 0 0.00050325 -0.3 0.00050375 0.3 0.000504 0 0.00050425 -0.3 0.00050475 0.3 0.000505 0 0.00050525 -0.3 0.00050575 0.3 0.000506 0 0.00050625 -0.3 0.00050675 0.3 0.000507 0 0.00050725 -0.3 0.00050775 0.3 0.000508 0 0.00050825 -0.3 0.00050875 0.3 0.000509 0 0.00050925 -0.3 0.00050975 0.3 0.00051 0 0.00051025 -0.3 0.00051075 0.3 0.000511 0 0.00051125 -0.3 0.00051175 0.3 0.000512 0 0.00051225 -0.3 0.00051275 0.3 0.000513 0 0.00051325 -0.3 0.00051375 0.3 0.000514 0 0.00051425 -0.3 0.00051475 0.3 0.000515 0 0.00051525 -0.3 0.00051575 0.3 0.000516 0 0.00051625 -0.3 0.00051675 0.3 0.000517 0 0.00051725 -0.3 0.00051775 0.3 0.000518 0 0.00051825 -0.3 0.00051875 0.3 0.000519 0 0.00051925 -0.3 0.00051975 0.3 0.00052 0 0.00052025 -0.3 0.00052075 0.3 0.000521 0 0.00052125 -0.3 0.00052175 0.3 0.000522 0 0.00052225 -0.3 0.00052275 0.3 0.000523 0 0.00052325 -0.3 0.00052375 0.3 0.000524 0 0.00052425 -0.3 0.00052475 0.3 0.000525 0 0.00052525 -0.3 0.00052575 0.3 0.000526 0 0.00052625 -0.3 0.00052675 0.3 0.000527 0 0.00052725 -0.3 0.00052775 0.3 0.000528 0 0.00052825 -0.3 0.00052875 0.3 0.000529 0 0.00052925 -0.3 0.00052975 0.3 0.00053 0 0.00053025 -0.3 0.00053075 0.3 0.000531 0 0.00053125 -0.3 0.00053175 0.3 0.000532 0 0.00053225 -0.3 0.00053275 0.3 0.000533 0 0.00053325 -0.3 0.00053375 0.3 0.000534 0 0.00053425 -0.3 0.00053475 0.3 0.000535 0 0.00053525 -0.3 0.00053575 0.3 0.000536 0 0.00053625 -0.3 0.00053675 0.3 0.000537 0 0.00053725 -0.3 0.00053775 0.3 0.000538 0 0.00053825 -0.3 0.00053875 0.3 0.000539 0 0.00053925 -0.3 0.00053975 0.3 0.00054 0 0.00054025 -0.3 0.00054075 0.3 0.000541 0 0.00054125 -0.3 0.00054175 0.3 0.000542 0 0.00054225 -0.3 0.00054275 0.3 0.000543 0 0.00054325 -0.3 0.00054375 0.3 0.000544 0 0.00054425 -0.3 0.00054475 0.3 0.000545 0 0.00054525 -0.3 0.00054575 0.3 0.000546 0 0.00054625 -0.3 0.00054675 0.3 0.000547 0 0.00054725 -0.3 0.00054775 0.3 0.000548 0 0.00054825 -0.3 0.00054875 0.3 0.000549 0 0.00054925 -0.3 0.00054975 0.3 0.00055 0 0.00055025 -0.3 0.00055075 0.3 0.000551 0 0.00055125 -0.3 0.00055175 0.3 0.000552 0 0.00055225 -0.3 0.00055275 0.3 0.000553 0 0.00055325 -0.3 0.00055375 0.3 0.000554 0 0.00055425 -0.3 0.00055475 0.3 0.000555 0 0.00055525 -0.3 0.00055575 0.3 0.000556 0 0.00055625 -0.3 0.00055675 0.3 0.000557 0 0.00055725 -0.3 0.00055775 0.3 0.000558 0 0.00055825 -0.3 0.00055875 0.3 0.000559 0 0.00055925 -0.3 0.00055975 0.3 0.00056 0 0.00056025 -0.3 0.00056075 0.3 0.000561 0 0.00056125 -0.3 0.00056175 0.3 0.000562 0 0.00056225 -0.3 0.00056275 0.3 0.000563 0 0.00056325 -0.3 0.00056375 0.3 0.000564 0 0.00056425 -0.3 0.00056475 0.3 0.000565 0 0.00056525 -0.3 0.00056575 0.3 0.000566 0 0.00056625 -0.3 0.00056675 0.3 0.000567 0 0.00056725 -0.3 0.00056775 0.3 0.000568 0 0.00056825 -0.3 0.00056875 0.3 0.000569 0 0.00056925 -0.3 0.00056975 0.3 0.00057 0 0.00057025 -0.3 0.00057075 0.3 0.000571 0 0.00057125 -0.3 0.00057175 0.3 0.000572 0 0.00057225 -0.3 0.00057275 0.3 0.000573 0 0.00057325 -0.3 0.00057375 0.3 0.000574 0 0.00057425 -0.3 0.00057475 0.3 0.000575 0 0.00057525 -0.3 0.00057575 0.3 0.000576 0 0.00057625 -0.3 0.00057675 0.3 0.000577 0 0.00057725 -0.3 0.00057775 0.3 0.000578 0 0.00057825 -0.3 0.00057875 0.3 0.000579 0 0.00057925 -0.3 0.00057975 0.3 0.00058 0 0.00058025 -0.3 0.00058075 0.3 0.000581 0 0.00058125 -0.3 0.00058175 0.3 0.000582 0 0.00058225 -0.3 0.00058275 0.3 0.000583 0 0.00058325 -0.3 0.00058375 0.3 0.000584 0 0.00058425 -0.3 0.00058475 0.3 0.000585 0 0.00058525 -0.3 0.00058575 0.3 0.000586 0 0.00058625 -0.3 0.00058675 0.3 0.000587 0 0.00058725 -0.3 0.00058775 0.3 0.000588 0 0.00058825 -0.3 0.00058875 0.3 0.000589 0 0.00058925 -0.3 0.00058975 0.3 0.00059 0 0.00059025 -0.3 0.00059075 0.3 0.000591 0 0.00059125 -0.3 0.00059175 0.3 0.000592 0 0.00059225 -0.3 0.00059275 0.3 0.000593 0 0.00059325 -0.3 0.00059375 0.3 0.000594 0 0.00059425 -0.3 0.00059475 0.3 0.000595 0 0.00059525 -0.3 0.00059575 0.3 0.000596 0 0.00059625 -0.3 0.00059675 0.3 0.000597 0 0.00059725 -0.3 0.00059775 0.3 0.000598 0 0.00059825 -0.3 0.00059875 0.3 0.000599 0 0.00059925 -0.3 0.00059975 0.3 0.0006 0 0.00060025 -0.3 0.00060075 0.3 0.000601 0 0.00060125 -0.3 0.00060175 0.3 0.000602 0 0.00060225 -0.3 0.00060275 0.3 0.000603 0 0.00060325 -0.3 0.00060375 0.3 0.000604 0 0.00060425 -0.3 0.00060475 0.3 0.000605 0 0.00060525 -0.3 0.00060575 0.3 0.000606 0 0.00060625 -0.3 0.00060675 0.3 0.000607 0 0.00060725 -0.3 0.00060775 0.3 0.000608 0 0.00060825 -0.3 0.00060875 0.3 0.000609 0 0.00060925 -0.3 0.00060975 0.3 0.00061 0 0.00061025 -0.3 0.00061075 0.3 0.000611 0 0.00061125 -0.3 0.00061175 0.3 0.000612 0 0.00061225 -0.3 0.00061275 0.3 0.000613 0 0.00061325 -0.3 0.00061375 0.3 0.000614 0 0.00061425 -0.3 0.00061475 0.3 0.000615 0 0.00061525 -0.3 0.00061575 0.3 0.000616 0 0.00061625 -0.3 0.00061675 0.3 0.000617 0 0.00061725 -0.3 0.00061775 0.3 0.000618 0 0.00061825 -0.3 0.00061875 0.3 0.000619 0 0.00061925 -0.3 0.00061975 0.3 0.00062 0 0.00062025 -0.3 0.00062075 0.3 0.000621 0 0.00062125 -0.3 0.00062175 0.3 0.000622 0 0.00062225 -0.3 0.00062275 0.3 0.000623 0 0.00062325 -0.3 0.00062375 0.3 0.000624 0 0.00062425 -0.3 0.00062475 0.3 0.000625 0 0.00062525 -0.3 0.00062575 0.3 0.000626 0 0.00062625 -0.3 0.00062675 0.3 0.000627 0 0.00062725 -0.3 0.00062775 0.3 0.000628 0 0.00062825 -0.3 0.00062875 0.3 0.000629 0 0.00062925 -0.3 0.00062975 0.3 0.00063 0 0.00063025 -0.3 0.00063075 0.3 0.000631 0 0.00063125 -0.3 0.00063175 0.3 0.000632 0 0.00063225 -0.3 0.00063275 0.3 0.000633 0 0.00063325 -0.3 0.00063375 0.3 0.000634 0 0.00063425 -0.3 0.00063475 0.3 0.000635 0 0.00063525 -0.3 0.00063575 0.3 0.000636 0 0.00063625 -0.3 0.00063675 0.3 0.000637 0 0.00063725 -0.3 0.00063775 0.3 0.000638 0 0.00063825 -0.3 0.00063875 0.3 0.000639 0 0.00063925 -0.3 0.00063975 0.3 0.00064 0 0.00064025 -0.3 0.00064075 0.3 0.000641 0 0.00064125 -0.3 0.00064175 0.3 0.000642 0 0.00064225 -0.3 0.00064275 0.3 0.000643 0 0.00064325 -0.3 0.00064375 0.3 0.000644 0 0.00064425 -0.3 0.00064475 0.3 0.000645 0 0.00064525 -0.3 0.00064575 0.3 0.000646 0 0.00064625 -0.3 0.00064675 0.3 0.000647 0 0.00064725 -0.3 0.00064775 0.3 0.000648 0 0.00064825 -0.3 0.00064875 0.3 0.000649 0 0.00064925 -0.3 0.00064975 0.3 0.00065 0 0.00065025 -0.3 0.00065075 0.3 0.000651 0 0.00065125 -0.3 0.00065175 0.3 0.000652 0 0.00065225 -0.3 0.00065275 0.3 0.000653 0 0.00065325 -0.3 0.00065375 0.3 0.000654 0 0.00065425 -0.3 0.00065475 0.3 0.000655 0 0.00065525 -0.3 0.00065575 0.3 0.000656 0 0.00065625 -0.3 0.00065675 0.3 0.000657 0 0.00065725 -0.3 0.00065775 0.3 0.000658 0 0.00065825 -0.3 0.00065875 0.3 0.000659 0 0.00065925 -0.3 0.00065975 0.3 0.00066 0 0.00066025 -0.3 0.00066075 0.3 0.000661 0 0.00066125 -0.3 0.00066175 0.3 0.000662 0 0.00066225 -0.3 0.00066275 0.3 0.000663 0 0.00066325 -0.3 0.00066375 0.3 0.000664 0 0.00066425 -0.3 0.00066475 0.3 0.000665 0 0.00066525 -0.3 0.00066575 0.3 0.000666 0 0.00066625 -0.3 0.00066675 0.3 0.000667 0 0.00066725 -0.3 0.00066775 0.3 0.000668 0 0.00066825 -0.3 0.00066875 0.3 0.000669 0 0.00066925 -0.3 0.00066975 0.3 0.00067 0 0.00067025 -0.3 0.00067075 0.3 0.000671 0 0.00067125 -0.3 0.00067175 0.3 0.000672 0 0.00067225 -0.3 0.00067275 0.3 0.000673 0 0.00067325 -0.3 0.00067375 0.3 0.000674 0 0.00067425 -0.3 0.00067475 0.3 0.000675 0 0.00067525 -0.3 0.00067575 0.3 0.000676 0 0.00067625 -0.3 0.00067675 0.3 0.000677 0 0.00067725 -0.3 0.00067775 0.3 0.000678 0 0.00067825 -0.3 0.00067875 0.3 0.000679 0 0.00067925 -0.3 0.00067975 0.3 0.00068 0 0.00068025 -0.3 0.00068075 0.3 0.000681 0 0.00068125 -0.3 0.00068175 0.3 0.000682 0 0.00068225 -0.3 0.00068275 0.3 0.000683 0 0.00068325 -0.3 0.00068375 0.3 0.000684 0 0.00068425 -0.3 0.00068475 0.3 0.000685 0 0.00068525 -0.3 0.00068575 0.3 0.000686 0 0.00068625 -0.3 0.00068675 0.3 0.000687 0 0.00068725 -0.3 0.00068775 0.3 0.000688 0 0.00068825 -0.3 0.00068875 0.3 0.000689 0 0.00068925 -0.3 0.00068975 0.3 0.00069 0 0.00069025 -0.3 0.00069075 0.3 0.000691 0 0.00069125 -0.3 0.00069175 0.3 0.000692 0 0.00069225 -0.3 0.00069275 0.3 0.000693 0 0.00069325 -0.3 0.00069375 0.3 0.000694 0 0.00069425 -0.3 0.00069475 0.3 0.000695 0 0.00069525 -0.3 0.00069575 0.3 0.000696 0 0.00069625 -0.3 0.00069675 0.3 0.000697 0 0.00069725 -0.3 0.00069775 0.3 0.000698 0 0.00069825 -0.3 0.00069875 0.3 0.000699 0 0.00069925 -0.3 0.00069975 0.3 0.0007 0 0.00070025 -0.3 0.00070075 0.3 0.000701 0 0.00070125 -0.3 0.00070175 0.3 0.000702 0 0.00070225 -0.3 0.00070275 0.3 0.000703 0 0.00070325 -0.3 0.00070375 0.3 0.000704 0 0.00070425 -0.3 0.00070475 0.3 0.000705 0 0.00070525 -0.3 0.00070575 0.3 0.000706 0 0.00070625 -0.3 0.00070675 0.3 0.000707 0 0.00070725 -0.3 0.00070775 0.3 0.000708 0 0.00070825 -0.3 0.00070875 0.3 0.000709 0 0.00070925 -0.3 0.00070975 0.3 0.00071 0 0.00071025 -0.3 0.00071075 0.3 0.000711 0 0.00071125 -0.3 0.00071175 0.3 0.000712 0 0.00071225 -0.3 0.00071275 0.3 0.000713 0 0.00071325 -0.3 0.00071375 0.3 0.000714 0 0.00071425 -0.3 0.00071475 0.3 0.000715 0 0.00071525 -0.3 0.00071575 0.3 0.000716 0 0.00071625 -0.3 0.00071675 0.3 0.000717 0 0.00071725 -0.3 0.00071775 0.3 0.000718 0 0.00071825 -0.3 0.00071875 0.3 0.000719 0 0.00071925 -0.3 0.00071975 0.3 0.00072 0 0.00072025 -0.3 0.00072075 0.3 0.000721 0 0.00072125 -0.3 0.00072175 0.3 0.000722 0 0.00072225 -0.3 0.00072275 0.3 0.000723 0 0.00072325 -0.3 0.00072375 0.3 0.000724 0 0.00072425 -0.3 0.00072475 0.3 0.000725 0 0.00072525 -0.3 0.00072575 0.3 0.000726 0 0.00072625 -0.3 0.00072675 0.3 0.000727 0 0.00072725 -0.3 0.00072775 0.3 0.000728 0 0.00072825 -0.3 0.00072875 0.3 0.000729 0 0.00072925 -0.3 0.00072975 0.3 0.00073 0 0.00073025 -0.3 0.00073075 0.3 0.000731 0 0.00073125 -0.3 0.00073175 0.3 0.000732 0 0.00073225 -0.3 0.00073275 0.3 0.000733 0 0.00073325 -0.3 0.00073375 0.3 0.000734 0 0.00073425 -0.3 0.00073475 0.3 0.000735 0 0.00073525 -0.3 0.00073575 0.3 0.000736 0 0.00073625 -0.3 0.00073675 0.3 0.000737 0 0.00073725 -0.3 0.00073775 0.3 0.000738 0 0.00073825 -0.3 0.00073875 0.3 0.000739 0 0.00073925 -0.3 0.00073975 0.3 0.00074 0 0.00074025 -0.3 0.00074075 0.3 0.000741 0 0.00074125 -0.3 0.00074175 0.3 0.000742 0 0.00074225 -0.3 0.00074275 0.3 0.000743 0 0.00074325 -0.3 0.00074375 0.3 0.000744 0 0.00074425 -0.3 0.00074475 0.3 0.000745 0 0.00074525 -0.3 0.00074575 0.3 0.000746 0 0.00074625 -0.3 0.00074675 0.3 0.000747 0 0.00074725 -0.3 0.00074775 0.3 0.000748 0 0.00074825 -0.3 0.00074875 0.3 0.000749 0 0.00074925 -0.3 0.00074975 0.3 0.00075 0 0.00075025 -0.3 0.00075075 0.3 0.000751 0 0.00075125 -0.3 0.00075175 0.3 0.000752 0 0.00075225 -0.3 0.00075275 0.3 0.000753 0 0.00075325 -0.3 0.00075375 0.3 0.000754 0 0.00075425 -0.3 0.00075475 0.3 0.000755 0 0.00075525 -0.3 0.00075575 0.3 0.000756 0 0.00075625 -0.3 0.00075675 0.3 0.000757 0 0.00075725 -0.3 0.00075775 0.3 0.000758 0 0.00075825 -0.3 0.00075875 0.3 0.000759 0 0.00075925 -0.3 0.00075975 0.3 0.00076 0 0.00076025 -0.3 0.00076075 0.3 0.000761 0 0.00076125 -0.3 0.00076175 0.3 0.000762 0 0.00076225 -0.3 0.00076275 0.3 0.000763 0 0.00076325 -0.3 0.00076375 0.3 0.000764 0 0.00076425 -0.3 0.00076475 0.3 0.000765 0 0.00076525 -0.3 0.00076575 0.3 0.000766 0 0.00076625 -0.3 0.00076675 0.3 0.000767 0 0.00076725 -0.3 0.00076775 0.3 0.000768 0 0.00076825 -0.3 0.00076875 0.3 0.000769 0 0.00076925 -0.3 0.00076975 0.3 0.00077 0 0.00077025 -0.3 0.00077075 0.3 0.000771 0 0.00077125 -0.3 0.00077175 0.3 0.000772 0 0.00077225 -0.3 0.00077275 0.3 0.000773 0 0.00077325 -0.3 0.00077375 0.3 0.000774 0 0.00077425 -0.3 0.00077475 0.3 0.000775 0 0.00077525 -0.3 0.00077575 0.3 0.000776 0 0.00077625 -0.3 0.00077675 0.3 0.000777 0 0.00077725 -0.3 0.00077775 0.3 0.000778 0 0.00077825 -0.3 0.00077875 0.3 0.000779 0 0.00077925 -0.3 0.00077975 0.3 0.00078 0 0.00078025 -0.3 0.00078075 0.3 0.000781 0 0.00078125 -0.3 0.00078175 0.3 0.000782 0 0.00078225 -0.3 0.00078275 0.3 0.000783 0 0.00078325 -0.3 0.00078375 0.3 0.000784 0 0.00078425 -0.3 0.00078475 0.3 0.000785 0 0.00078525 -0.3 0.00078575 0.3 0.000786 0 0.00078625 -0.3 0.00078675 0.3 0.000787 0 0.00078725 -0.3 0.00078775 0.3 0.000788 0 0.00078825 -0.3 0.00078875 0.3 0.000789 0 0.00078925 -0.3 0.00078975 0.3 0.00079 0 0.00079025 -0.3 0.00079075 0.3 0.000791 0 0.00079125 -0.3 0.00079175 0.3 0.000792 0 0.00079225 -0.3 0.00079275 0.3 0.000793 0 0.00079325 -0.3 0.00079375 0.3 0.000794 0 0.00079425 -0.3 0.00079475 0.3 0.000795 0 0.00079525 -0.3 0.00079575 0.3 0.000796 0 0.00079625 -0.3 0.00079675 0.3 0.000797 0 0.00079725 -0.3 0.00079775 0.3 0.000798 0 0.00079825 -0.3 0.00079875 0.3 0.000799 0 0.00079925 -0.3 0.00079975 0.3 0.0008 0 0.00080025 -0.3 0.00080075 0.3 0.000801 0 0.00080125 -0.3 0.00080175 0.3 0.000802 0 0.00080225 -0.3 0.00080275 0.3 0.000803 0 0.00080325 -0.3 0.00080375 0.3 0.000804 0 0.00080425 -0.3 0.00080475 0.3 0.000805 0 0.00080525 -0.3 0.00080575 0.3 0.000806 0 0.00080625 -0.3 0.00080675 0.3 0.000807 0 0.00080725 -0.3 0.00080775 0.3 0.000808 0 0.00080825 -0.3 0.00080875 0.3 0.000809 0 0.00080925 -0.3 0.00080975 0.3 0.00081 0 0.00081025 -0.3 0.00081075 0.3 0.000811 0 0.00081125 -0.3 0.00081175 0.3 0.000812 0 0.00081225 -0.3 0.00081275 0.3 0.000813 0 0.00081325 -0.3 0.00081375 0.3 0.000814 0 0.00081425 -0.3 0.00081475 0.3 0.000815 0 0.00081525 -0.3 0.00081575 0.3 0.000816 0 0.00081625 -0.3 0.00081675 0.3 0.000817 0 0.00081725 -0.3 0.00081775 0.3 0.000818 0 0.00081825 -0.3 0.00081875 0.3 0.000819 0 0.00081925 -0.3 0.00081975 0.3 0.00082 0 0.00082025 -0.3 0.00082075 0.3 0.000821 0 0.00082125 -0.3 0.00082175 0.3 0.000822 0 0.00082225 -0.3 0.00082275 0.3 0.000823 0 0.00082325 -0.3 0.00082375 0.3 0.000824 0 0.00082425 -0.3 0.00082475 0.3 0.000825 0 0.00082525 -0.3 0.00082575 0.3 0.000826 0 0.00082625 -0.3 0.00082675 0.3 0.000827 0 0.00082725 -0.3 0.00082775 0.3 0.000828 0 0.00082825 -0.3 0.00082875 0.3 0.000829 0 0.00082925 -0.3 0.00082975 0.3 0.00083 0 0.00083025 -0.3 0.00083075 0.3 0.000831 0 0.00083125 -0.3 0.00083175 0.3 0.000832 0 0.00083225 -0.3 0.00083275 0.3 0.000833 0 0.00083325 -0.3 0.00083375 0.3 0.000834 0 0.00083425 -0.3 0.00083475 0.3 0.000835 0 0.00083525 -0.3 0.00083575 0.3 0.000836 0 0.00083625 -0.3 0.00083675 0.3 0.000837 0 0.00083725 -0.3 0.00083775 0.3 0.000838 0 0.00083825 -0.3 0.00083875 0.3 0.000839 0 0.00083925 -0.3 0.00083975 0.3 0.00084 0 0.00084025 -0.3 0.00084075 0.3 0.000841 0 0.00084125 -0.3 0.00084175 0.3 0.000842 0 0.00084225 -0.3 0.00084275 0.3 0.000843 0 0.00084325 -0.3 0.00084375 0.3 0.000844 0 0.00084425 -0.3 0.00084475 0.3 0.000845 0 0.00084525 -0.3 0.00084575 0.3 0.000846 0 0.00084625 -0.3 0.00084675 0.3 0.000847 0 0.00084725 -0.3 0.00084775 0.3 0.000848 0 0.00084825 -0.3 0.00084875 0.3 0.000849 0 0.00084925 -0.3 0.00084975 0.3 0.00085 0 0.00085025 -0.3 0.00085075 0.3 0.000851 0 0.00085125 -0.3 0.00085175 0.3 0.000852 0 0.00085225 -0.3 0.00085275 0.3 0.000853 0 0.00085325 -0.3 0.00085375 0.3 0.000854 0 0.00085425 -0.3 0.00085475 0.3 0.000855 0 0.00085525 -0.3 0.00085575 0.3 0.000856 0 0.00085625 -0.3 0.00085675 0.3 0.000857 0 0.00085725 -0.3 0.00085775 0.3 0.000858 0 0.00085825 -0.3 0.00085875 0.3 0.000859 0 0.00085925 -0.3 0.00085975 0.3 0.00086 0 0.00086025 -0.3 0.00086075 0.3 0.000861 0 0.00086125 -0.3 0.00086175 0.3 0.000862 0 0.00086225 -0.3 0.00086275 0.3 0.000863 0 0.00086325 -0.3 0.00086375 0.3 0.000864 0 0.00086425 -0.3 0.00086475 0.3 0.000865 0 0.00086525 -0.3 0.00086575 0.3 0.000866 0 0.00086625 -0.3 0.00086675 0.3 0.000867 0 0.00086725 -0.3 0.00086775 0.3 0.000868 0 0.00086825 -0.3 0.00086875 0.3 0.000869 0 0.00086925 -0.3 0.00086975 0.3 0.00087 0 0.00087025 -0.3 0.00087075 0.3 0.000871 0 0.00087125 -0.3 0.00087175 0.3 0.000872 0 0.00087225 -0.3 0.00087275 0.3 0.000873 0 0.00087325 -0.3 0.00087375 0.3 0.000874 0 0.00087425 -0.3 0.00087475 0.3 0.000875 0 0.00087525 -0.3 0.00087575 0.3 0.000876 0 0.00087625 -0.3 0.00087675 0.3 0.000877 0 0.00087725 -0.3 0.00087775 0.3 0.000878 0 0.00087825 -0.3 0.00087875 0.3 0.000879 0 0.00087925 -0.3 0.00087975 0.3 0.00088 0 0.00088025 -0.3 0.00088075 0.3 0.000881 0 0.00088125 -0.3 0.00088175 0.3 0.000882 0 0.00088225 -0.3 0.00088275 0.3 0.000883 0 0.00088325 -0.3 0.00088375 0.3 0.000884 0 0.00088425 -0.3 0.00088475 0.3 0.000885 0 0.00088525 -0.3 0.00088575 0.3 0.000886 0 0.00088625 -0.3 0.00088675 0.3 0.000887 0 0.00088725 -0.3 0.00088775 0.3 0.000888 0 0.00088825 -0.3 0.00088875 0.3 0.000889 0 0.00088925 -0.3 0.00088975 0.3 0.00089 0 0.00089025 -0.3 0.00089075 0.3 0.000891 0 0.00089125 -0.3 0.00089175 0.3 0.000892 0 0.00089225 -0.3 0.00089275 0.3 0.000893 0 0.00089325 -0.3 0.00089375 0.3 0.000894 0 0.00089425 -0.3 0.00089475 0.3 0.000895 0 0.00089525 -0.3 0.00089575 0.3 0.000896 0 0.00089625 -0.3 0.00089675 0.3 0.000897 0 0.00089725 -0.3 0.00089775 0.3 0.000898 0 0.00089825 -0.3 0.00089875 0.3 0.000899 0 0.00089925 -0.3 0.00089975 0.3 0.0009 0 0.00090025 -0.3 0.00090075 0.3 0.000901 0 0.00090125 -0.3 0.00090175 0.3 0.000902 0 0.00090225 -0.3 0.00090275 0.3 0.000903 0 0.00090325 -0.3 0.00090375 0.3 0.000904 0 0.00090425 -0.3 0.00090475 0.3 0.000905 0 0.00090525 -0.3 0.00090575 0.3 0.000906 0 0.00090625 -0.3 0.00090675 0.3 0.000907 0 0.00090725 -0.3 0.00090775 0.3 0.000908 0 0.00090825 -0.3 0.00090875 0.3 0.000909 0 0.00090925 -0.3 0.00090975 0.3 0.00091 0 0.00091025 -0.3 0.00091075 0.3 0.000911 0 0.00091125 -0.3 0.00091175 0.3 0.000912 0 0.00091225 -0.3 0.00091275 0.3 0.000913 0 0.00091325 -0.3 0.00091375 0.3 0.000914 0 0.00091425 -0.3 0.00091475 0.3 0.000915 0 0.00091525 -0.3 0.00091575 0.3 0.000916 0 0.00091625 -0.3 0.00091675 0.3 0.000917 0 0.00091725 -0.3 0.00091775 0.3 0.000918 0 0.00091825 -0.3 0.00091875 0.3 0.000919 0 0.00091925 -0.3 0.00091975 0.3 0.00092 0 0.00092025 -0.3 0.00092075 0.3 0.000921 0 0.00092125 -0.3 0.00092175 0.3 0.000922 0 0.00092225 -0.3 0.00092275 0.3 0.000923 0 0.00092325 -0.3 0.00092375 0.3 0.000924 0 0.00092425 -0.3 0.00092475 0.3 0.000925 0 0.00092525 -0.3 0.00092575 0.3 0.000926 0 0.00092625 -0.3 0.00092675 0.3 0.000927 0 0.00092725 -0.3 0.00092775 0.3 0.000928 0 0.00092825 -0.3 0.00092875 0.3 0.000929 0 0.00092925 -0.3 0.00092975 0.3 0.00093 0 0.00093025 -0.3 0.00093075 0.3 0.000931 0 0.00093125 -0.3 0.00093175 0.3 0.000932 0 0.00093225 -0.3 0.00093275 0.3 0.000933 0 0.00093325 -0.3 0.00093375 0.3 0.000934 0 0.00093425 -0.3 0.00093475 0.3 0.000935 0 0.00093525 -0.3 0.00093575 0.3 0.000936 0 0.00093625 -0.3 0.00093675 0.3 0.000937 0 0.00093725 -0.3 0.00093775 0.3 0.000938 0 0.00093825 -0.3 0.00093875 0.3 0.000939 0 0.00093925 -0.3 0.00093975 0.3 0.00094 0 0.00094025 -0.3 0.00094075 0.3 0.000941 0 0.00094125 -0.3 0.00094175 0.3 0.000942 0 0.00094225 -0.3 0.00094275 0.3 0.000943 0 0.00094325 -0.3 0.00094375 0.3 0.000944 0 0.00094425 -0.3 0.00094475 0.3 0.000945 0 0.00094525 -0.3 0.00094575 0.3 0.000946 0 0.00094625 -0.3 0.00094675 0.3 0.000947 0 0.00094725 -0.3 0.00094775 0.3 0.000948 0 0.00094825 -0.3 0.00094875 0.3 0.000949 0 0.00094925 -0.3 0.00094975 0.3 0.00095 0 0.00095025 -0.3 0.00095075 0.3 0.000951 0 0.00095125 -0.3 0.00095175 0.3 0.000952 0 0.00095225 -0.3 0.00095275 0.3 0.000953 0 0.00095325 -0.3 0.00095375 0.3 0.000954 0 0.00095425 -0.3 0.00095475 0.3 0.000955 0 0.00095525 -0.3 0.00095575 0.3 0.000956 0 0.00095625 -0.3 0.00095675 0.3 0.000957 0 0.00095725 -0.3 0.00095775 0.3 0.000958 0 0.00095825 -0.3 0.00095875 0.3 0.000959 0 0.00095925 -0.3 0.00095975 0.3 0.00096 0 0.00096025 -0.3 0.00096075 0.3 0.000961 0 0.00096125 -0.3 0.00096175 0.3 0.000962 0 0.00096225 -0.3 0.00096275 0.3 0.000963 0 0.00096325 -0.3 0.00096375 0.3 0.000964 0 0.00096425 -0.3 0.00096475 0.3 0.000965 0 0.00096525 -0.3 0.00096575 0.3 0.000966 0 0.00096625 -0.3 0.00096675 0.3 0.000967 0 0.00096725 -0.3 0.00096775 0.3 0.000968 0 0.00096825 -0.3 0.00096875 0.3 0.000969 0 0.00096925 -0.3 0.00096975 0.3 0.00097 0 0.00097025 -0.3 0.00097075 0.3 0.000971 0 0.00097125 -0.3 0.00097175 0.3 0.000972 0 0.00097225 -0.3 0.00097275 0.3 0.000973 0 0.00097325 -0.3 0.00097375 0.3 0.000974 0 0.00097425 -0.3 0.00097475 0.3 0.000975 0 0.00097525 -0.3 0.00097575 0.3 0.000976 0 0.00097625 -0.3 0.00097675 0.3 0.000977 0 0.00097725 -0.3 0.00097775 0.3 0.000978 0 0.00097825 -0.3 0.00097875 0.3 0.000979 0 0.00097925 -0.3 0.00097975 0.3 0.00098 0 0.00098025 -0.3 0.00098075 0.3 0.000981 0 0.00098125 -0.3 0.00098175 0.3 0.000982 0 0.00098225 -0.3 0.00098275 0.3 0.000983 0 0.00098325 -0.3 0.00098375 0.3 0.000984 0 0.00098425 -0.3 0.00098475 0.3 0.000985 0 0.00098525 -0.3 0.00098575 0.3 0.000986 0 0.00098625 -0.3 0.00098675 0.3 0.000987 0 0.00098725 -0.3 0.00098775 0.3 0.000988 0 0.00098825 -0.3 0.00098875 0.3 0.000989 0 0.00098925 -0.3 0.00098975 0.3 0.00099 0 0.00099025 -0.3 0.00099075 0.3 0.000991 0 0.00099125 -0.3 0.00099175 0.3 0.000992 0 0.00099225 -0.3 0.00099275 0.3 0.000993 0 0.00099325 -0.3 0.00099375 0.3 0.000994 0 0.00099425 -0.3 0.00099475 0.3 0.000995 0 0.00099525 -0.3 0.00099575 0.3 0.000996 0 0.00099625 -0.3 0.00099675 0.3 0.000997 0 0.00099725 -0.3 0.00099775 0.3 0.000998 0 0.00099825 -0.3 0.00099875 0.3 0.000999 0 0.00099925 -0.3 0.00099975 0.3 0.001 0 0.00100025 -0.3 0.00100075 0.3 0.001001 0 0.00100125 -0.3 0.00100175 0.3 0.001002 0 0.00100225 -0.3 0.00100275 0.3 0.001003 0 0.00100325 -0.3 0.00100375 0.3 0.001004 0 0.00100425 -0.3 0.00100475 0.3 0.001005 0 0.001007 0)
.control
pre_osdi ../build/fecap_nls.osdi
set wr_singlescale
set wr_vecnames
set numdgt=15
tran 2e-08 0.001007
wrdata small_signal.dat v(p1) v(q1) i(v1) v(p2) v(q2) i(v2) v(p3) v(q3) i(v3)
.endc
.end
