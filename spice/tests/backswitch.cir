* Back-switching with V_dep and screening
* Generated by spice/compare_ngspice.py --write-decks (do not edit by hand).
* Run from any directory:  ngspice_con -b backswitch.cir
* It loads ../build/fecap_nls.osdi (python spice/build_osdi.py) and writes
* backswitch.dat into the current working directory.
.include ../params/generic.inc
.temp 25
.options method=gear reltol=1e-4

* generic card with: vdep=1 tau_s=0.0001
.model fecap_mod fecap_nls vdep=1 tau_s=0.0001
* 3 V, 10 us write from s0 = -1, then 1 ms at 0 V; vdep = 1.0 V, tau_s = 100 us
N1 p1 0 q1 fecap_mod s0=-1 area=1e-10
V1 p1 0 pwl(0 0 1e-06 0 1.1e-06 3 1.11e-05 3 1.12e-05 0 0.0010112 0)
.control
pre_osdi ../build/fecap_nls.osdi
set wr_singlescale
set wr_vecnames
set numdgt=15
tran 5e-08 0.0010112
wrdata backswitch.dat v(p1) v(q1) i(v1)
.endc
.end
