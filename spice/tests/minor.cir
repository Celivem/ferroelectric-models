* Minor loops of growing amplitude
* Generated by spice/compare_ngspice.py --write-decks (do not edit by hand).
* Run from any directory:  ngspice_con -b minor.cir
* It loads ../build/fecap_nls.osdi (python spice/build_osdi.py) and writes
* minor.dat into the current working directory.
.include ../params/generic.inc
.temp 25
.options method=gear reltol=1e-4

* minor loops of growing amplitude (1.2-3.0 V, 10 kHz slope), from s0 = -1
N1 p1 0 q1 fecap_generic s0=-1 area=1e-10
V1 p1 0 pwl(0 0 1e-05 1.2 3e-05 -1.2 5.33333e-05 1.6 8e-05 -1.6 0.00011 2 0.000143333 -2 0.00018 2.4 0.00022 -2.4 0.000265 3 0.000315 -3 0.00034 0)
.control
pre_osdi ../build/fecap_nls.osdi
set wr_singlescale
set wr_vecnames
set numdgt=15
tran 2e-08 0.00034
wrdata minor.dat v(p1) v(q1) i(v1)
.endc
.end
