* Reversible depinning pool (E18) at 85 C
* Generated by spice/compare_ngspice.py --write-decks (do not edit by hand).
* Run from any directory:  ngspice_con -b depin.cir
* It loads ../build/fecap_nls.osdi (python spice/build_osdi.py) and writes
* depin.dat into the current working directory.
.include ../params/generic.inc
.temp 85
.options method=gear reltol=1e-4

* generic card with: wk_fq=0.4 wk_rho=0.3 wk_tr=2e-06 wk_q1=2e-06 wk_q2=0.0002 wk_nq=2 wk_ea=0.2
.model fecap_mod fecap_nls wk_fq=0.4 wk_rho=0.3 wk_tr=2e-06 wk_q1=2e-06 wk_q2=0.0002 wk_nq=2 wk_ea=0.2
* 6 bipolar +-3 V 5 us pulse pairs, 200 us rest, 3 more pairs; pristine
N1 p1 0 q1 fecap_mod s0=-1 area=1e-10
V1 p1 0 pwl(0 0 1e-06 0 1.1e-06 3 6.1e-06 3 6.2e-06 0 1.12e-05 0 1.13e-05 -3 1.63e-05 -3 1.64e-05 0 2.14e-05 0 2.15e-05 3 2.65e-05 3 2.66e-05 0 3.16e-05 0 3.17e-05 -3 3.67e-05 -3 3.68e-05 0 4.18e-05 0 4.19e-05 3 4.69e-05 3 4.7e-05 0 5.2e-05 0 5.21e-05 -3 5.71e-05 -3 5.72e-05 0 6.22e-05 0 6.23e-05 3 6.73e-05 3 6.74e-05 0 7.24e-05 0 7.25e-05 -3 7.75e-05 -3 7.76e-05 0 8.26e-05 0 8.27e-05 3 8.77e-05 3 8.78e-05 0 9.28e-05 0 9.29e-05 -3 9.79e-05 -3 9.8e-05 0 0.000103 0 0.0001031 3 0.0001081 3 0.0001082 0 0.0001132 0 0.0001133 -3 0.0001183 -3 0.0001184 0 0.0001234 0 0.0001235 0 0.0003235 0 0.0003236 3 0.0003286 3 0.0003287 0 0.0003337 0 0.0003338 -3 0.0003388 -3 0.0003389 0 0.0003439 0 0.000344 3 0.000349 3 0.0003491 0 0.0003541 0 0.0003542 -3 0.0003592 -3 0.0003593 0 0.0003643 0 0.0003644 3 0.0003694 3 0.0003695 0 0.0003745 0 0.0003746 -3 0.0003796 -3 0.0003797 0 0.0003847 0)
* same, starting half depinned (zq0 = 0.5)
N2 p2 0 q2 fecap_mod s0=-1 area=1e-10 zq0=0.5
V2 p2 0 pwl(0 0 1e-06 0 1.1e-06 3 6.1e-06 3 6.2e-06 0 1.12e-05 0 1.13e-05 -3 1.63e-05 -3 1.64e-05 0 2.14e-05 0 2.15e-05 3 2.65e-05 3 2.66e-05 0 3.16e-05 0 3.17e-05 -3 3.67e-05 -3 3.68e-05 0 4.18e-05 0 4.19e-05 3 4.69e-05 3 4.7e-05 0 5.2e-05 0 5.21e-05 -3 5.71e-05 -3 5.72e-05 0 6.22e-05 0 6.23e-05 3 6.73e-05 3 6.74e-05 0 7.24e-05 0 7.25e-05 -3 7.75e-05 -3 7.76e-05 0 8.26e-05 0 8.27e-05 3 8.77e-05 3 8.78e-05 0 9.28e-05 0 9.29e-05 -3 9.79e-05 -3 9.8e-05 0 0.000103 0 0.0001031 3 0.0001081 3 0.0001082 0 0.0001132 0 0.0001133 -3 0.0001183 -3 0.0001184 0 0.0001234 0 0.0001235 0 0.0003235 0 0.0003236 3 0.0003286 3 0.0003287 0 0.0003337 0 0.0003338 -3 0.0003388 -3 0.0003389 0 0.0003439 0 0.000344 3 0.000349 3 0.0003491 0 0.0003541 0 0.0003542 -3 0.0003592 -3 0.0003593 0 0.0003643 0 0.0003644 3 0.0003694 3 0.0003695 0 0.0003745 0 0.0003746 -3 0.0003796 -3 0.0003797 0 0.0003847 0)
.control
pre_osdi ../build/fecap_nls.osdi
set wr_singlescale
set wr_vecnames
set numdgt=15
tran 5e-08 0.0003847
wrdata depin.dat v(p1) v(q1) i(v1) v(p2) v(q2) i(v2)
.endc
.end
