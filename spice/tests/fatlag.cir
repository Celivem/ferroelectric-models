* Lagged field-time fatigue (E19) and fatigue-induced leakage (E20)
* Generated by spice/compare_ngspice.py --write-decks (do not edit by hand).
* Run from any directory:  ngspice_con -b fatlag.cir
* It loads ../build/fecap_nls.osdi (python spice/build_osdi.py) and writes
* fatlag.dat into the current working directory.
.include ../params/generic.inc
.temp 25
.options method=gear reltol=1e-4

* generic card with: fat_d=0.4 fat_tf=0.0003 fat_nf=2 fat_kf=0.7 fat_tl=2e-06 fat_lk=200 fat_lm=1.5 g_oh=100
.model fecap_mod fecap_nls fat_d=0.4 fat_tf=0.0003 fat_nf=2 fat_kf=0.7 fat_tl=2e-06 fat_lk=200 fat_lm=1.5 g_oh=100
* bipolar +-3 V pulses of 2, 8 and 20 us, then a 30 us hold at 1.5 V
N1 p1 0 q1 fecap_mod s0=-1 area=1e-10
V1 p1 0 pwl(0 0 1e-06 0 1.5e-06 3 3.5e-06 3 4e-06 0 8e-06 0 8.5e-06 -3 1.05e-05 -3 1.1e-05 0 1.5e-05 0 1.55e-05 3 1.75e-05 3 1.8e-05 0 2.2e-05 0 2.25e-05 -3 2.45e-05 -3 2.5e-05 0 2.9e-05 0 2.95e-05 3 3.75e-05 3 3.8e-05 0 4.2e-05 0 4.25e-05 -3 5.05e-05 -3 5.1e-05 0 5.5e-05 0 5.55e-05 3 6.35e-05 3 6.4e-05 0 6.8e-05 0 6.85e-05 -3 7.65e-05 -3 7.7e-05 0 8.1e-05 0 8.15e-05 3 0.0001015 3 0.000102 0 0.000106 0 0.0001065 -3 0.0001265 -3 0.000127 0 0.000131 0 0.0001315 3 0.0001515 3 0.000152 0 0.000156 0 0.0001565 -3 0.0001765 -3 0.000177 0 0.000181 0 0.0001815 1.5 0.0002115 1.5)
.control
pre_osdi ../build/fecap_nls.osdi
set wr_singlescale
set wr_vecnames
set numdgt=15
tran 5e-08 0.0002115
wrdata fatlag.dat v(p1) v(q1) i(v1)
.endc
.end
