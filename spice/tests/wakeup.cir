* Wake-up (pinned fraction and split bias released by cycling)
* Generated by spice/compare_ngspice.py --write-decks (do not edit by hand).
* Run from any directory:  ngspice_con -b wakeup.cir
* It loads ../build/fecap_nls.osdi (python spice/build_osdi.py) and writes
* wakeup.dat into the current working directory.
.include ../params/generic.inc
.temp 25
.options method=gear reltol=1e-4

* generic card with: wk_fp=0.3 wk_vsp=0.5 wk_nw=3 wk_kw=0.8
.model fecap_mod fecap_nls wk_fp=0.3 wk_vsp=0.5 wk_nw=3 wk_kw=0.8
* +-3 V triangle, 100 kHz, 8 cycles from the pristine state
N1 p1 0 q1 fecap_mod s0=-1 area=1e-10
V1 p1 0 pwl(0 0 2.5e-06 3 7.5e-06 -3 1.25e-05 3 1.75e-05 -3 2.25e-05 3 2.75e-05 -3 3.25e-05 3 3.75e-05 -3 4.25e-05 3 4.75e-05 -3 5.25e-05 3 5.75e-05 -3 6.25e-05 3 6.75e-05 -3 7.25e-05 3 7.75e-05 -3 8e-05 0)
.control
pre_osdi ../build/fecap_nls.osdi
set wr_singlescale
set wr_vecnames
set numdgt=15
tran 5e-09 8e-05
wrdata wakeup.dat v(p1) v(q1) i(v1)
.endc
.end
