* Imprint (log-spaced trapping states) at 85 C
* Generated by spice/compare_ngspice.py --write-decks (do not edit by hand).
* Run from any directory:  ngspice_con -b imprint.cir
* It loads ../build/fecap_nls.osdi (python spice/build_osdi.py) and writes
* imprint.dat into the current working directory.
.include ../params/generic.inc
.temp 85
.options method=gear reltol=1e-4

* the 50 ns imprint states follow the switching: tighter step control
.options reltol=2e-5
* generic card with: imp_v=0.4 imp_t1=1e-07 imp_t2=0.01 imp_ea=0.1
.model fecap_mod fecap_nls imp_v=0.4 imp_t1=1e-07 imp_t2=0.01 imp_ea=0.1
* +3 V write, 3 ms at 0 V, -1.8 V and +1.8 V 5 us pulses; imprint states on, 85 C
N1 p1 0 q1 fecap_mod s0=-1 area=1e-10
V1 p1 0 pwl(0 0 5e-07 0 6e-07 3 2.6e-06 3 2.7e-06 0 0.0030027 0 0.0030028 -1.8 0.0030078 -1.8 0.0030079 0 0.0030579 0 0.003058 1.8 0.003063 1.8 0.0030631 0 0.0031131 0)
.control
pre_osdi ../build/fecap_nls.osdi
set wr_singlescale
set wr_vecnames
set numdgt=15
tran 1e-06 0.0031131
wrdata imprint.dat v(p1) v(q1) i(v1)
.endc
.end
