* History instance parameters nw0, af0, si0
* Generated by spice/compare_ngspice.py --write-decks (do not edit by hand).
* Run from any directory:  ngspice_con -b history.cir
* It loads ../build/fecap_nls.osdi (python spice/build_osdi.py) and writes
* history.dat into the current working directory.
.include ../params/generic.inc
.temp 25
.options method=gear reltol=1e-4

* generic card with: wk_fp=0.25 wk_vsp=0.4 wk_nw=1000 fat_d=0.3 fat_tf=1000 fat_ns=1e+06 fat_kf=0.5 fat_ke=0.2 imp_v=0.3
.model fecap_mod fecap_nls wk_fp=0.25 wk_vsp=0.4 wk_nw=1000 fat_d=0.3 fat_tf=1000 fat_ns=1e+06 fat_kf=0.5 fat_ke=0.2 imp_v=0.3
* pristine, 1.5 cycles at 10 kHz
N1 p1 0 q1 fecap_mod s0=-1 area=1e-10
V1 p1 0 pwl(0 0 2.5e-05 3 7.5e-05 -3 0.000125 3 0.00015 0)
* nw0 = 1e5, af0 = 0.3, si0 = -0.5, 1.5 cycles at 10 kHz
N2 p2 0 q2 fecap_mod s0=-1 area=1e-10 nw0=100000 af0=0.3 si0=-0.5
V2 p2 0 pwl(0 0 2.5e-05 3 7.5e-05 -3 0.000125 3 0.00015 0)
.control
pre_osdi ../build/fecap_nls.osdi
set wr_singlescale
set wr_vecnames
set numdgt=15
tran 2e-08 0.00015
wrdata history.dat v(p1) v(q1) i(v1) v(p2) v(q2) i(v2)
.endc
.end
