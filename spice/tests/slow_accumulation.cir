* 200 cycles of a 1 MHz triangle
* Generated by spice/compare_ngspice.py --write-decks (do not edit by hand).
* Run from any directory:  ngspice_con -b slow_accumulation.cir
* It loads ../build/fecap_nls.osdi (python spice/build_osdi.py) and writes
* slow_accumulation.dat into the current working directory.
.include ../params/generic.inc
.temp 25
.options method=gear reltol=1e-4

* +-0.8 V from a partially switched state, 200 cycles at 1 MHz
N1 p1 0 q1 fecap_generic s0=-1 area=1e-10
V1 p1 0 pwl(0 0 5e-07 0 5.1e-07 2 1.51e-06 2 1.52e-06 0 5e-06 0 5.25e-06 -0.8 5.75e-06 0.8 6e-06 0 6.25e-06 -0.8 6.75e-06 0.8 7e-06 0 7.25e-06 -0.8 7.75e-06 0.8 8e-06 0 8.25e-06 -0.8 8.75e-06 0.8 9e-06 0 9.25e-06 -0.8 9.75e-06 0.8 1e-05 0 1.025e-05 -0.8 1.075e-05 0.8 1.1e-05 0 1.125e-05 -0.8 1.175e-05 0.8 1.2e-05 0 1.225e-05 -0.8 1.275e-05 0.8 1.3e-05 0 1.325e-05 -0.8 1.375e-05 0.8 1.4e-05 0 1.425e-05 -0.8 1.475e-05 0.8 1.5e-05 0 1.525e-05 -0.8 1.575e-05 0.8 1.6e-05 0 1.625e-05 -0.8 1.675e-05 0.8 1.7e-05 0 1.725e-05 -0.8 1.775e-05 0.8 1.8e-05 0 1.825e-05 -0.8 1.875e-05 0.8 1.9e-05 0 1.925e-05 -0.8 1.975e-05 0.8 2e-05 0 2.025e-05 -0.8 2.075e-05 0.8 2.1e-05 0 2.125e-05 -0.8 2.175e-05 0.8 2.2e-05 0 2.225e-05 -0.8 2.275e-05 0.8 2.3e-05 0 2.325e-05 -0.8 2.375e-05 0.8 2.4e-05 0 2.425e-05 -0.8 2.475e-05 0.8 2.5e-05 0 2.525e-05 -0.8 2.575e-05 0.8 2.6e-05 0 2.625e-05 -0.8 2.675e-05 0.8 2.7e-05 0 2.725e-05 -0.8 2.775e-05 0.8 2.8e-05 0 2.825e-05 -0.8 2.875e-05 0.8 2.9e-05 0 2.925e-05 -0.8 2.975e-05 0.8 3e-05 0 3.025e-05 -0.8 3.075e-05 0.8 3.1e-05 0 3.125e-05 -0.8 3.175e-05 0.8 3.2e-05 0 3.225e-05 -0.8 3.275e-05 0.8 3.3e-05 0 3.325e-05 -0.8 3.375e-05 0.8 3.4e-05 0 3.425e-05 -0.8 3.475e-05 0.8 3.5e-05 0 3.525e-05 -0.8 3.575e-05 0.8 3.6e-05 0 3.625e-05 -0.8 3.675e-05 0.8 3.7e-05 0 3.725e-05 -0.8 3.775e-05 0.8 3.8e-05 0 3.825e-05 -0.8 3.875e-05 0.8 3.9e-05 0 3.925e-05 -0.8 3.975e-05 0.8 4e-05 0 4.025e-05 -0.8 4.075e-05 0.8 4.1e-05 0 4.125e-05 -0.8 4.175e-05 0.8 4.2e-05 0 4.225e-05 -0.8 4.275e-05 0.8 4.3e-05 0 4.325e-05 -0.8 4.375e-05 0.8 4.4e-05 0 4.425e-05 -0.8 4.475e-05 0.8 4.5e-05 0 4.525e-05 -0.8 4.575e-05 0.8 4.6e-05 0 4.625e-05 -0.8 4.675e-05 0.8 4.7e-05 0 4.725e-05 -0.8 4.775e-05 0.8 4.8e-05 0 4.825e-05 -0.8 4.875e-05 0.8 4.9e-05 0 4.925e-05 -0.8 4.975e-05 0.8 5e-05 0 5.025e-05 -0.8 5.075e-05 0.8 5.1e-05 0 5.125e-05 -0.8 5.175e-05 0.8 5.2e-05 0 5.225e-05 -0.8 5.275e-05 0.8 5.3e-05 0 5.325e-05 -0.8 5.375e-05 0.8 5.4e-05 0 5.425e-05 -0.8 5.475e-05 0.8 5.5e-05 0 5.525e-05 -0.8 5.575e-05 0.8 5.6e-05 0 5.625e-05 -0.8 5.675e-05 0.8 5.7e-05 0 5.725e-05 -0.8 5.775e-05 0.8 5.8e-05 0 5.825e-05 -0.8 5.875e-05 0.8 5.9e-05 0 5.925e-05 -0.8 5.975e-05 0.8 6e-05 0 6.025e-05 -0.8 6.075e-05 0.8 6.1e-05 0 6.125e-05 -0.8 6.175e-05 0.8 6.2e-05 0 6.225e-05 -0.8 6.275e-05 0.8 6.3e-05 0 6.325e-05 -0.8 6.375e-05 0.8 6.4e-05 0 6.425e-05 -0.8 6.475e-05 0.8 6.5e-05 0 6.525e-05 -0.8 6.575e-05 0.8 6.6e-05 0 6.625e-05 -0.8 6.675e-05 0.8 6.7e-05 0 6.725e-05 -0.8 6.775e-05 0.8 6.8e-05 0 6.825e-05 -0.8 6.875e-05 0.8 6.9e-05 0 6.925e-05 -0.8 6.975e-05 0.8 7e-05 0 7.025e-05 -0.8 7.075e-05 0.8 7.1e-05 0 7.125e-05 -0.8 7.175e-05 0.8 7.2e-05 0 7.225e-05 -0.8 7.275e-05 0.8 7.3e-05 0 7.325e-05 -0.8 7.375e-05 0.8 7.4e-05 0 7.425e-05 -0.8 7.475e-05 0.8 7.5e-05 0 7.525e-05 -0.8 7.575e-05 0.8 7.6e-05 0 7.625e-05 -0.8 7.675e-05 0.8 7.7e-05 0 7.725e-05 -0.8 7.775e-05 0.8 7.8e-05 0 7.825e-05 -0.8 7.875e-05 0.8 7.9e-05 0 7.925e-05 -0.8 7.975e-05 0.8 8e-05 0 8.025e-05 -0.8 8.075e-05 0.8 8.1e-05 0 8.125e-05 -0.8 8.175e-05 0.8 8.2e-05 0 8.225e-05 -0.8 8.275e-05 0.8 8.3e-05 0 8.325e-05 -0.8 8.375e-05 0.8 8.4e-05 0 8.425e-05 -0.8 8.475e-05 0.8 8.5e-05 0 8.525e-05 -0.8 8.575e-05 0.8 8.6e-05 0 8.625e-05 -0.8 8.675e-05 0.8 8.7e-05 0 8.725e-05 -0.8 8.775e-05 0.8 8.8e-05 0 8.825e-05 -0.8 8.875e-05 0.8 8.9e-05 0 8.925e-05 -0.8 8.975e-05 0.8 9e-05 0 9.025e-05 -0.8 9.075e-05 0.8 9.1e-05 0 9.125e-05 -0.8 9.175e-05 0.8 9.2e-05 0 9.225e-05 -0.8 9.275e-05 0.8 9.3e-05 0 9.325e-05 -0.8 9.375e-05 0.8 9.4e-05 0 9.425e-05 -0.8 9.475e-05 0.8 9.5e-05 0 9.525e-05 -0.8 9.575e-05 0.8 9.6e-05 0 9.625e-05 -0.8 9.675e-05 0.8 9.7e-05 0 9.725e-05 -0.8 9.775e-05 0.8 9.8e-05 0 9.825e-05 -0.8 9.875e-05 0.8 9.9e-05 0 9.925e-05 -0.8 9.975e-05 0.8 0.0001 0 0.00010025 -0.8 0.00010075 0.8 0.000101 0 0.00010125 -0.8 0.00010175 0.8 0.000102 0 0.00010225 -0.8 0.00010275 0.8 0.000103 0 0.00010325 -0.8 0.00010375 0.8 0.000104 0 0.00010425 -0.8 0.00010475 0.8 0.000105 0 0.00010525 -0.8 0.00010575 0.8 0.000106 0 0.00010625 -0.8 0.00010675 0.8 0.000107 0 0.00010725 -0.8 0.00010775 0.8 0.000108 0 0.00010825 -0.8 0.00010875 0.8 0.000109 0 0.00010925 -0.8 0.00010975 0.8 0.00011 0 0.00011025 -0.8 0.00011075 0.8 0.000111 0 0.00011125 -0.8 0.00011175 0.8 0.000112 0 0.00011225 -0.8 0.00011275 0.8 0.000113 0 0.00011325 -0.8 0.00011375 0.8 0.000114 0 0.00011425 -0.8 0.00011475 0.8 0.000115 0 0.00011525 -0.8 0.00011575 0.8 0.000116 0 0.00011625 -0.8 0.00011675 0.8 0.000117 0 0.00011725 -0.8 0.00011775 0.8 0.000118 0 0.00011825 -0.8 0.00011875 0.8 0.000119 0 0.00011925 -0.8 0.00011975 0.8 0.00012 0 0.00012025 -0.8 0.00012075 0.8 0.000121 0 0.00012125 -0.8 0.00012175 0.8 0.000122 0 0.00012225 -0.8 0.00012275 0.8 0.000123 0 0.00012325 -0.8 0.00012375 0.8 0.000124 0 0.00012425 -0.8 0.00012475 0.8 0.000125 0 0.00012525 -0.8 0.00012575 0.8 0.000126 0 0.00012625 -0.8 0.00012675 0.8 0.000127 0 0.00012725 -0.8 0.00012775 0.8 0.000128 0 0.00012825 -0.8 0.00012875 0.8 0.000129 0 0.00012925 -0.8 0.00012975 0.8 0.00013 0 0.00013025 -0.8 0.00013075 0.8 0.000131 0 0.00013125 -0.8 0.00013175 0.8 0.000132 0 0.00013225 -0.8 0.00013275 0.8 0.000133 0 0.00013325 -0.8 0.00013375 0.8 0.000134 0 0.00013425 -0.8 0.00013475 0.8 0.000135 0 0.00013525 -0.8 0.00013575 0.8 0.000136 0 0.00013625 -0.8 0.00013675 0.8 0.000137 0 0.00013725 -0.8 0.00013775 0.8 0.000138 0 0.00013825 -0.8 0.00013875 0.8 0.000139 0 0.00013925 -0.8 0.00013975 0.8 0.00014 0 0.00014025 -0.8 0.00014075 0.8 0.000141 0 0.00014125 -0.8 0.00014175 0.8 0.000142 0 0.00014225 -0.8 0.00014275 0.8 0.000143 0 0.00014325 -0.8 0.00014375 0.8 0.000144 0 0.00014425 -0.8 0.00014475 0.8 0.000145 0 0.00014525 -0.8 0.00014575 0.8 0.000146 0 0.00014625 -0.8 0.00014675 0.8 0.000147 0 0.00014725 -0.8 0.00014775 0.8 0.000148 0 0.00014825 -0.8 0.00014875 0.8 0.000149 0 0.00014925 -0.8 0.00014975 0.8 0.00015 0 0.00015025 -0.8 0.00015075 0.8 0.000151 0 0.00015125 -0.8 0.00015175 0.8 0.000152 0 0.00015225 -0.8 0.00015275 0.8 0.000153 0 0.00015325 -0.8 0.00015375 0.8 0.000154 0 0.00015425 -0.8 0.00015475 0.8 0.000155 0 0.00015525 -0.8 0.00015575 0.8 0.000156 0 0.00015625 -0.8 0.00015675 0.8 0.000157 0 0.00015725 -0.8 0.00015775 0.8 0.000158 0 0.00015825 -0.8 0.00015875 0.8 0.000159 0 0.00015925 -0.8 0.00015975 0.8 0.00016 0 0.00016025 -0.8 0.00016075 0.8 0.000161 0 0.00016125 -0.8 0.00016175 0.8 0.000162 0 0.00016225 -0.8 0.00016275 0.8 0.000163 0 0.00016325 -0.8 0.00016375 0.8 0.000164 0 0.00016425 -0.8 0.00016475 0.8 0.000165 0 0.00016525 -0.8 0.00016575 0.8 0.000166 0 0.00016625 -0.8 0.00016675 0.8 0.000167 0 0.00016725 -0.8 0.00016775 0.8 0.000168 0 0.00016825 -0.8 0.00016875 0.8 0.000169 0 0.00016925 -0.8 0.00016975 0.8 0.00017 0 0.00017025 -0.8 0.00017075 0.8 0.000171 0 0.00017125 -0.8 0.00017175 0.8 0.000172 0 0.00017225 -0.8 0.00017275 0.8 0.000173 0 0.00017325 -0.8 0.00017375 0.8 0.000174 0 0.00017425 -0.8 0.00017475 0.8 0.000175 0 0.00017525 -0.8 0.00017575 0.8 0.000176 0 0.00017625 -0.8 0.00017675 0.8 0.000177 0 0.00017725 -0.8 0.00017775 0.8 0.000178 0 0.00017825 -0.8 0.00017875 0.8 0.000179 0 0.00017925 -0.8 0.00017975 0.8 0.00018 0 0.00018025 -0.8 0.00018075 0.8 0.000181 0 0.00018125 -0.8 0.00018175 0.8 0.000182 0 0.00018225 -0.8 0.00018275 0.8 0.000183 0 0.00018325 -0.8 0.00018375 0.8 0.000184 0 0.00018425 -0.8 0.00018475 0.8 0.000185 0 0.00018525 -0.8 0.00018575 0.8 0.000186 0 0.00018625 -0.8 0.00018675 0.8 0.000187 0 0.00018725 -0.8 0.00018775 0.8 0.000188 0 0.00018825 -0.8 0.00018875 0.8 0.000189 0 0.00018925 -0.8 0.00018975 0.8 0.00019 0 0.00019025 -0.8 0.00019075 0.8 0.000191 0 0.00019125 -0.8 0.00019175 0.8 0.000192 0 0.00019225 -0.8 0.00019275 0.8 0.000193 0 0.00019325 -0.8 0.00019375 0.8 0.000194 0 0.00019425 -0.8 0.00019475 0.8 0.000195 0 0.00019525 -0.8 0.00019575 0.8 0.000196 0 0.00019625 -0.8 0.00019675 0.8 0.000197 0 0.00019725 -0.8 0.00019775 0.8 0.000198 0 0.00019825 -0.8 0.00019875 0.8 0.000199 0 0.00019925 -0.8 0.00019975 0.8 0.0002 0 0.00020025 -0.8 0.00020075 0.8 0.000201 0 0.00020125 -0.8 0.00020175 0.8 0.000202 0 0.00020225 -0.8 0.00020275 0.8 0.000203 0 0.00020325 -0.8 0.00020375 0.8 0.000204 0 0.00020425 -0.8 0.00020475 0.8 0.000205 0 0.000207 0)
.control
pre_osdi ../build/fecap_nls.osdi
set wr_singlescale
set wr_vecnames
set numdgt=15
tran 2e-08 0.000207
wrdata slow_accumulation.dat v(p1) v(q1) i(v1)
.endc
.end
