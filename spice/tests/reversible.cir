* Reversible response with frev = 0.5 and C_w, C_r
* Generated by spice/compare_ngspice.py --write-decks (do not edit by hand).
* Run from any directory:  ngspice_con -b reversible.cir
* It loads ../build/fecap_nls.osdi (python spice/build_osdi.py) and writes
* reversible.dat into the current working directory.
.include ../params/generic.inc
.temp 25
.options method=gear reltol=1e-4

* generic card with: frev=0.5 c_w=0.005 c_r=0.003 tau_r=2e-08
.model fecap_mod fecap_nls frev=0.5 c_w=0.005 c_r=0.003 tau_r=2e-08
* +-0.67 V reads, a 1.8 V partial switch, reads again; frev = 0.5, C_w, C_r on
N1 p1 0 q1 fecap_mod s0=-1 area=1e-10
V1 p1 0 pwl(0 0 2e-07 0 2.05e-07 0.67 1.205e-06 0.67 1.21e-06 0 2.21e-06 0 2.215e-06 -0.67 3.215e-06 -0.67 3.22e-06 0 4.22e-06 0 4.225e-06 1.8 5.225e-06 1.8 5.23e-06 0 6.23e-06 0 6.235e-06 0.67 7.235e-06 0.67 7.24e-06 0 8.24e-06 0)
.control
pre_osdi ../build/fecap_nls.osdi
set wr_singlescale
set wr_vecnames
set numdgt=15
tran 2e-09 8.24e-06
wrdata reversible.dat v(p1) v(q1) i(v1)
.endc
.end
