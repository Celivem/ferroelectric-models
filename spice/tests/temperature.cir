* Temperature coefficients at 85 C
* Generated by spice/compare_ngspice.py --write-decks (do not edit by hand).
* Run from any directory:  ngspice_con -b temperature.cir
* It loads ../build/fecap_nls.osdi (python spice/build_osdi.py) and writes
* temperature.dat into the current working directory.
.include ../params/generic.inc
.temp 85
.options method=gear reltol=1e-4

* generic card with: tc_ea=-0.001 tc_ps=-0.0005 tc_tau=-0.001 tc_c=0.001 g_oh=0.01
.model fecap_mod fecap_nls tc_ea=-0.001 tc_ps=-0.0005 tc_tau=-0.001 tc_c=0.001 g_oh=0.01
* 2.0 V / 1 us, then -1.5 V / 3 us at 85 C with temperature coefficients
N1 p1 0 q1 fecap_mod s0=-1 area=1e-10
V1 p1 0 pwl(0 0 5e-07 0 5.1e-07 2 1.51e-06 2 1.52e-06 0 3.52e-06 0 3.53e-06 -1.5 6.53e-06 -1.5 6.54e-06 0 8.54e-06 0)
.control
pre_osdi ../build/fecap_nls.osdi
set wr_singlescale
set wr_vecnames
set numdgt=15
tran 5e-09 8.54e-06
wrdata temperature.dat v(p1) v(q1) i(v1)
.endc
.end
