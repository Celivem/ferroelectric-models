* PUND sequence (preset, P, U, N, D) at 3 V
* Generated by spice/compare_ngspice.py --write-decks (do not edit by hand).
* Run from any directory:  ngspice_con -b pund.cir
* It loads ../build/fecap_nls.osdi (python spice/build_osdi.py) and writes
* pund.dat into the current working directory.
.include ../params/generic.inc
.temp 25
.options method=gear reltol=1e-4

* PUND 3 V, 10 us pulses, 10 us gaps, preset to -; start s0 = +1
N1 p1 0 q1 fecap_generic s0=1 area=1e-10
V1 p1 0 pwl(0 0 1e-06 0 1.1e-06 -3 1.11e-05 -3 1.12e-05 0 2.12e-05 0 2.13e-05 3 3.13e-05 3 3.14e-05 0 4.14e-05 0 4.15e-05 3 5.15e-05 3 5.16e-05 0 6.16e-05 0 6.17e-05 -3 7.17e-05 -3 7.18e-05 0 8.18e-05 0 8.19e-05 -3 9.19e-05 -3 9.2e-05 0 0.000102 0)
.control
pre_osdi ../build/fecap_nls.osdi
set wr_singlescale
set wr_vecnames
set numdgt=15
tran 1e-08 0.000102
wrdata pund.dat v(p1) v(q1) i(v1)
.endc
.end
